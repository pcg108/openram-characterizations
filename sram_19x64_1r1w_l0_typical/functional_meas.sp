.meas tran vdout1_0ck40 FIND v(dout1_0) AT=50.05n

.meas tran vdout1_1ck40 FIND v(dout1_1) AT=50.05n

.meas tran vdout1_2ck40 FIND v(dout1_2) AT=50.05n

.meas tran vdout1_3ck40 FIND v(dout1_3) AT=50.05n

.meas tran vdout1_4ck40 FIND v(dout1_4) AT=50.05n

.meas tran vdout1_5ck40 FIND v(dout1_5) AT=50.05n

.meas tran vdout1_6ck40 FIND v(dout1_6) AT=50.05n

.meas tran vdout1_7ck40 FIND v(dout1_7) AT=50.05n

.meas tran vdout1_8ck40 FIND v(dout1_8) AT=50.05n

.meas tran vdout1_9ck40 FIND v(dout1_9) AT=50.05n

.meas tran vdout1_10ck40 FIND v(dout1_10) AT=50.05n

.meas tran vdout1_11ck40 FIND v(dout1_11) AT=50.05n

.meas tran vdout1_12ck40 FIND v(dout1_12) AT=50.05n

.meas tran vdout1_13ck40 FIND v(dout1_13) AT=50.05n

.meas tran vdout1_14ck40 FIND v(dout1_14) AT=50.05n

.meas tran vdout1_15ck40 FIND v(dout1_15) AT=50.05n

.meas tran vdout1_16ck40 FIND v(dout1_16) AT=50.05n

.meas tran vdout1_17ck40 FIND v(dout1_17) AT=50.05n

.meas tran vdout1_18ck40 FIND v(dout1_18) AT=50.05n

.meas tran vdout1_0ck50 FIND v(dout1_0) AT=60.05n

.meas tran vdout1_1ck50 FIND v(dout1_1) AT=60.05n

.meas tran vdout1_2ck50 FIND v(dout1_2) AT=60.05n

.meas tran vdout1_3ck50 FIND v(dout1_3) AT=60.05n

.meas tran vdout1_4ck50 FIND v(dout1_4) AT=60.05n

.meas tran vdout1_5ck50 FIND v(dout1_5) AT=60.05n

.meas tran vdout1_6ck50 FIND v(dout1_6) AT=60.05n

.meas tran vdout1_7ck50 FIND v(dout1_7) AT=60.05n

.meas tran vdout1_8ck50 FIND v(dout1_8) AT=60.05n

.meas tran vdout1_9ck50 FIND v(dout1_9) AT=60.05n

.meas tran vdout1_10ck50 FIND v(dout1_10) AT=60.05n

.meas tran vdout1_11ck50 FIND v(dout1_11) AT=60.05n

.meas tran vdout1_12ck50 FIND v(dout1_12) AT=60.05n

.meas tran vdout1_13ck50 FIND v(dout1_13) AT=60.05n

.meas tran vdout1_14ck50 FIND v(dout1_14) AT=60.05n

.meas tran vdout1_15ck50 FIND v(dout1_15) AT=60.05n

.meas tran vdout1_16ck50 FIND v(dout1_16) AT=60.05n

.meas tran vdout1_17ck50 FIND v(dout1_17) AT=60.05n

.meas tran vdout1_18ck50 FIND v(dout1_18) AT=60.05n

.meas tran vdout1_0ck140 FIND v(dout1_0) AT=150.05n

.meas tran vdout1_1ck140 FIND v(dout1_1) AT=150.05n

.meas tran vdout1_2ck140 FIND v(dout1_2) AT=150.05n

.meas tran vdout1_3ck140 FIND v(dout1_3) AT=150.05n

.meas tran vdout1_4ck140 FIND v(dout1_4) AT=150.05n

.meas tran vdout1_5ck140 FIND v(dout1_5) AT=150.05n

.meas tran vdout1_6ck140 FIND v(dout1_6) AT=150.05n

.meas tran vdout1_7ck140 FIND v(dout1_7) AT=150.05n

.meas tran vdout1_8ck140 FIND v(dout1_8) AT=150.05n

.meas tran vdout1_9ck140 FIND v(dout1_9) AT=150.05n

.meas tran vdout1_10ck140 FIND v(dout1_10) AT=150.05n

.meas tran vdout1_11ck140 FIND v(dout1_11) AT=150.05n

.meas tran vdout1_12ck140 FIND v(dout1_12) AT=150.05n

.meas tran vdout1_13ck140 FIND v(dout1_13) AT=150.05n

.meas tran vdout1_14ck140 FIND v(dout1_14) AT=150.05n

.meas tran vdout1_15ck140 FIND v(dout1_15) AT=150.05n

.meas tran vdout1_16ck140 FIND v(dout1_16) AT=150.05n

.meas tran vdout1_17ck140 FIND v(dout1_17) AT=150.05n

.meas tran vdout1_18ck140 FIND v(dout1_18) AT=150.05n

.meas tran vdout1_0ck170 FIND v(dout1_0) AT=180.05n

.meas tran vdout1_1ck170 FIND v(dout1_1) AT=180.05n

.meas tran vdout1_2ck170 FIND v(dout1_2) AT=180.05n

.meas tran vdout1_3ck170 FIND v(dout1_3) AT=180.05n

.meas tran vdout1_4ck170 FIND v(dout1_4) AT=180.05n

.meas tran vdout1_5ck170 FIND v(dout1_5) AT=180.05n

.meas tran vdout1_6ck170 FIND v(dout1_6) AT=180.05n

.meas tran vdout1_7ck170 FIND v(dout1_7) AT=180.05n

.meas tran vdout1_8ck170 FIND v(dout1_8) AT=180.05n

.meas tran vdout1_9ck170 FIND v(dout1_9) AT=180.05n

.meas tran vdout1_10ck170 FIND v(dout1_10) AT=180.05n

.meas tran vdout1_11ck170 FIND v(dout1_11) AT=180.05n

.meas tran vdout1_12ck170 FIND v(dout1_12) AT=180.05n

.meas tran vdout1_13ck170 FIND v(dout1_13) AT=180.05n

.meas tran vdout1_14ck170 FIND v(dout1_14) AT=180.05n

.meas tran vdout1_15ck170 FIND v(dout1_15) AT=180.05n

.meas tran vdout1_16ck170 FIND v(dout1_16) AT=180.05n

.meas tran vdout1_17ck170 FIND v(dout1_17) AT=180.05n

.meas tran vdout1_18ck170 FIND v(dout1_18) AT=180.05n

.meas tran vdout1_0ck180 FIND v(dout1_0) AT=190.05n

.meas tran vdout1_1ck180 FIND v(dout1_1) AT=190.05n

.meas tran vdout1_2ck180 FIND v(dout1_2) AT=190.05n

.meas tran vdout1_3ck180 FIND v(dout1_3) AT=190.05n

.meas tran vdout1_4ck180 FIND v(dout1_4) AT=190.05n

.meas tran vdout1_5ck180 FIND v(dout1_5) AT=190.05n

.meas tran vdout1_6ck180 FIND v(dout1_6) AT=190.05n

.meas tran vdout1_7ck180 FIND v(dout1_7) AT=190.05n

.meas tran vdout1_8ck180 FIND v(dout1_8) AT=190.05n

.meas tran vdout1_9ck180 FIND v(dout1_9) AT=190.05n

.meas tran vdout1_10ck180 FIND v(dout1_10) AT=190.05n

.meas tran vdout1_11ck180 FIND v(dout1_11) AT=190.05n

.meas tran vdout1_12ck180 FIND v(dout1_12) AT=190.05n

.meas tran vdout1_13ck180 FIND v(dout1_13) AT=190.05n

.meas tran vdout1_14ck180 FIND v(dout1_14) AT=190.05n

.meas tran vdout1_15ck180 FIND v(dout1_15) AT=190.05n

.meas tran vdout1_16ck180 FIND v(dout1_16) AT=190.05n

.meas tran vdout1_17ck180 FIND v(dout1_17) AT=190.05n

.meas tran vdout1_18ck180 FIND v(dout1_18) AT=190.05n

.meas tran vdout1_0ck200 FIND v(dout1_0) AT=210.05n

.meas tran vdout1_1ck200 FIND v(dout1_1) AT=210.05n

.meas tran vdout1_2ck200 FIND v(dout1_2) AT=210.05n

.meas tran vdout1_3ck200 FIND v(dout1_3) AT=210.05n

.meas tran vdout1_4ck200 FIND v(dout1_4) AT=210.05n

.meas tran vdout1_5ck200 FIND v(dout1_5) AT=210.05n

.meas tran vdout1_6ck200 FIND v(dout1_6) AT=210.05n

.meas tran vdout1_7ck200 FIND v(dout1_7) AT=210.05n

.meas tran vdout1_8ck200 FIND v(dout1_8) AT=210.05n

.meas tran vdout1_9ck200 FIND v(dout1_9) AT=210.05n

.meas tran vdout1_10ck200 FIND v(dout1_10) AT=210.05n

.meas tran vdout1_11ck200 FIND v(dout1_11) AT=210.05n

.meas tran vdout1_12ck200 FIND v(dout1_12) AT=210.05n

.meas tran vdout1_13ck200 FIND v(dout1_13) AT=210.05n

.meas tran vdout1_14ck200 FIND v(dout1_14) AT=210.05n

.meas tran vdout1_15ck200 FIND v(dout1_15) AT=210.05n

.meas tran vdout1_16ck200 FIND v(dout1_16) AT=210.05n

.meas tran vdout1_17ck200 FIND v(dout1_17) AT=210.05n

.meas tran vdout1_18ck200 FIND v(dout1_18) AT=210.05n

.meas tran vdout1_0ck220 FIND v(dout1_0) AT=230.05n

.meas tran vdout1_1ck220 FIND v(dout1_1) AT=230.05n

.meas tran vdout1_2ck220 FIND v(dout1_2) AT=230.05n

.meas tran vdout1_3ck220 FIND v(dout1_3) AT=230.05n

.meas tran vdout1_4ck220 FIND v(dout1_4) AT=230.05n

.meas tran vdout1_5ck220 FIND v(dout1_5) AT=230.05n

.meas tran vdout1_6ck220 FIND v(dout1_6) AT=230.05n

.meas tran vdout1_7ck220 FIND v(dout1_7) AT=230.05n

.meas tran vdout1_8ck220 FIND v(dout1_8) AT=230.05n

.meas tran vdout1_9ck220 FIND v(dout1_9) AT=230.05n

.meas tran vdout1_10ck220 FIND v(dout1_10) AT=230.05n

.meas tran vdout1_11ck220 FIND v(dout1_11) AT=230.05n

.meas tran vdout1_12ck220 FIND v(dout1_12) AT=230.05n

.meas tran vdout1_13ck220 FIND v(dout1_13) AT=230.05n

.meas tran vdout1_14ck220 FIND v(dout1_14) AT=230.05n

.meas tran vdout1_15ck220 FIND v(dout1_15) AT=230.05n

.meas tran vdout1_16ck220 FIND v(dout1_16) AT=230.05n

.meas tran vdout1_17ck220 FIND v(dout1_17) AT=230.05n

.meas tran vdout1_18ck220 FIND v(dout1_18) AT=230.05n

.meas tran vdout1_0ck230 FIND v(dout1_0) AT=240.05n

.meas tran vdout1_1ck230 FIND v(dout1_1) AT=240.05n

.meas tran vdout1_2ck230 FIND v(dout1_2) AT=240.05n

.meas tran vdout1_3ck230 FIND v(dout1_3) AT=240.05n

.meas tran vdout1_4ck230 FIND v(dout1_4) AT=240.05n

.meas tran vdout1_5ck230 FIND v(dout1_5) AT=240.05n

.meas tran vdout1_6ck230 FIND v(dout1_6) AT=240.05n

.meas tran vdout1_7ck230 FIND v(dout1_7) AT=240.05n

.meas tran vdout1_8ck230 FIND v(dout1_8) AT=240.05n

.meas tran vdout1_9ck230 FIND v(dout1_9) AT=240.05n

.meas tran vdout1_10ck230 FIND v(dout1_10) AT=240.05n

.meas tran vdout1_11ck230 FIND v(dout1_11) AT=240.05n

.meas tran vdout1_12ck230 FIND v(dout1_12) AT=240.05n

.meas tran vdout1_13ck230 FIND v(dout1_13) AT=240.05n

.meas tran vdout1_14ck230 FIND v(dout1_14) AT=240.05n

.meas tran vdout1_15ck230 FIND v(dout1_15) AT=240.05n

.meas tran vdout1_16ck230 FIND v(dout1_16) AT=240.05n

.meas tran vdout1_17ck230 FIND v(dout1_17) AT=240.05n

.meas tran vdout1_18ck230 FIND v(dout1_18) AT=240.05n

.meas tran vdout1_0ck280 FIND v(dout1_0) AT=290.05n

.meas tran vdout1_1ck280 FIND v(dout1_1) AT=290.05n

.meas tran vdout1_2ck280 FIND v(dout1_2) AT=290.05n

.meas tran vdout1_3ck280 FIND v(dout1_3) AT=290.05n

.meas tran vdout1_4ck280 FIND v(dout1_4) AT=290.05n

.meas tran vdout1_5ck280 FIND v(dout1_5) AT=290.05n

.meas tran vdout1_6ck280 FIND v(dout1_6) AT=290.05n

.meas tran vdout1_7ck280 FIND v(dout1_7) AT=290.05n

.meas tran vdout1_8ck280 FIND v(dout1_8) AT=290.05n

.meas tran vdout1_9ck280 FIND v(dout1_9) AT=290.05n

.meas tran vdout1_10ck280 FIND v(dout1_10) AT=290.05n

.meas tran vdout1_11ck280 FIND v(dout1_11) AT=290.05n

.meas tran vdout1_12ck280 FIND v(dout1_12) AT=290.05n

.meas tran vdout1_13ck280 FIND v(dout1_13) AT=290.05n

.meas tran vdout1_14ck280 FIND v(dout1_14) AT=290.05n

.meas tran vdout1_15ck280 FIND v(dout1_15) AT=290.05n

.meas tran vdout1_16ck280 FIND v(dout1_16) AT=290.05n

.meas tran vdout1_17ck280 FIND v(dout1_17) AT=290.05n

.meas tran vdout1_18ck280 FIND v(dout1_18) AT=290.05n

.meas tran vdout1_0ck370 FIND v(dout1_0) AT=380.05n

.meas tran vdout1_1ck370 FIND v(dout1_1) AT=380.05n

.meas tran vdout1_2ck370 FIND v(dout1_2) AT=380.05n

.meas tran vdout1_3ck370 FIND v(dout1_3) AT=380.05n

.meas tran vdout1_4ck370 FIND v(dout1_4) AT=380.05n

.meas tran vdout1_5ck370 FIND v(dout1_5) AT=380.05n

.meas tran vdout1_6ck370 FIND v(dout1_6) AT=380.05n

.meas tran vdout1_7ck370 FIND v(dout1_7) AT=380.05n

.meas tran vdout1_8ck370 FIND v(dout1_8) AT=380.05n

.meas tran vdout1_9ck370 FIND v(dout1_9) AT=380.05n

.meas tran vdout1_10ck370 FIND v(dout1_10) AT=380.05n

.meas tran vdout1_11ck370 FIND v(dout1_11) AT=380.05n

.meas tran vdout1_12ck370 FIND v(dout1_12) AT=380.05n

.meas tran vdout1_13ck370 FIND v(dout1_13) AT=380.05n

.meas tran vdout1_14ck370 FIND v(dout1_14) AT=380.05n

.meas tran vdout1_15ck370 FIND v(dout1_15) AT=380.05n

.meas tran vdout1_16ck370 FIND v(dout1_16) AT=380.05n

.meas tran vdout1_17ck370 FIND v(dout1_17) AT=380.05n

.meas tran vdout1_18ck370 FIND v(dout1_18) AT=380.05n

.meas tran vdout1_0ck420 FIND v(dout1_0) AT=430.05n

.meas tran vdout1_1ck420 FIND v(dout1_1) AT=430.05n

.meas tran vdout1_2ck420 FIND v(dout1_2) AT=430.05n

.meas tran vdout1_3ck420 FIND v(dout1_3) AT=430.05n

.meas tran vdout1_4ck420 FIND v(dout1_4) AT=430.05n

.meas tran vdout1_5ck420 FIND v(dout1_5) AT=430.05n

.meas tran vdout1_6ck420 FIND v(dout1_6) AT=430.05n

.meas tran vdout1_7ck420 FIND v(dout1_7) AT=430.05n

.meas tran vdout1_8ck420 FIND v(dout1_8) AT=430.05n

.meas tran vdout1_9ck420 FIND v(dout1_9) AT=430.05n

.meas tran vdout1_10ck420 FIND v(dout1_10) AT=430.05n

.meas tran vdout1_11ck420 FIND v(dout1_11) AT=430.05n

.meas tran vdout1_12ck420 FIND v(dout1_12) AT=430.05n

.meas tran vdout1_13ck420 FIND v(dout1_13) AT=430.05n

.meas tran vdout1_14ck420 FIND v(dout1_14) AT=430.05n

.meas tran vdout1_15ck420 FIND v(dout1_15) AT=430.05n

.meas tran vdout1_16ck420 FIND v(dout1_16) AT=430.05n

.meas tran vdout1_17ck420 FIND v(dout1_17) AT=430.05n

.meas tran vdout1_18ck420 FIND v(dout1_18) AT=430.05n

.meas tran vdout1_0ck430 FIND v(dout1_0) AT=440.05n

.meas tran vdout1_1ck430 FIND v(dout1_1) AT=440.05n

.meas tran vdout1_2ck430 FIND v(dout1_2) AT=440.05n

.meas tran vdout1_3ck430 FIND v(dout1_3) AT=440.05n

.meas tran vdout1_4ck430 FIND v(dout1_4) AT=440.05n

.meas tran vdout1_5ck430 FIND v(dout1_5) AT=440.05n

.meas tran vdout1_6ck430 FIND v(dout1_6) AT=440.05n

.meas tran vdout1_7ck430 FIND v(dout1_7) AT=440.05n

.meas tran vdout1_8ck430 FIND v(dout1_8) AT=440.05n

.meas tran vdout1_9ck430 FIND v(dout1_9) AT=440.05n

.meas tran vdout1_10ck430 FIND v(dout1_10) AT=440.05n

.meas tran vdout1_11ck430 FIND v(dout1_11) AT=440.05n

.meas tran vdout1_12ck430 FIND v(dout1_12) AT=440.05n

.meas tran vdout1_13ck430 FIND v(dout1_13) AT=440.05n

.meas tran vdout1_14ck430 FIND v(dout1_14) AT=440.05n

.meas tran vdout1_15ck430 FIND v(dout1_15) AT=440.05n

.meas tran vdout1_16ck430 FIND v(dout1_16) AT=440.05n

.meas tran vdout1_17ck430 FIND v(dout1_17) AT=440.05n

.meas tran vdout1_18ck430 FIND v(dout1_18) AT=440.05n

.meas tran vdout1_0ck440 FIND v(dout1_0) AT=450.05n

.meas tran vdout1_1ck440 FIND v(dout1_1) AT=450.05n

.meas tran vdout1_2ck440 FIND v(dout1_2) AT=450.05n

.meas tran vdout1_3ck440 FIND v(dout1_3) AT=450.05n

.meas tran vdout1_4ck440 FIND v(dout1_4) AT=450.05n

.meas tran vdout1_5ck440 FIND v(dout1_5) AT=450.05n

.meas tran vdout1_6ck440 FIND v(dout1_6) AT=450.05n

.meas tran vdout1_7ck440 FIND v(dout1_7) AT=450.05n

.meas tran vdout1_8ck440 FIND v(dout1_8) AT=450.05n

.meas tran vdout1_9ck440 FIND v(dout1_9) AT=450.05n

.meas tran vdout1_10ck440 FIND v(dout1_10) AT=450.05n

.meas tran vdout1_11ck440 FIND v(dout1_11) AT=450.05n

.meas tran vdout1_12ck440 FIND v(dout1_12) AT=450.05n

.meas tran vdout1_13ck440 FIND v(dout1_13) AT=450.05n

.meas tran vdout1_14ck440 FIND v(dout1_14) AT=450.05n

.meas tran vdout1_15ck440 FIND v(dout1_15) AT=450.05n

.meas tran vdout1_16ck440 FIND v(dout1_16) AT=450.05n

.meas tran vdout1_17ck440 FIND v(dout1_17) AT=450.05n

.meas tran vdout1_18ck440 FIND v(dout1_18) AT=450.05n

.meas tran vdout1_0ck450 FIND v(dout1_0) AT=460.05n

.meas tran vdout1_1ck450 FIND v(dout1_1) AT=460.05n

.meas tran vdout1_2ck450 FIND v(dout1_2) AT=460.05n

.meas tran vdout1_3ck450 FIND v(dout1_3) AT=460.05n

.meas tran vdout1_4ck450 FIND v(dout1_4) AT=460.05n

.meas tran vdout1_5ck450 FIND v(dout1_5) AT=460.05n

.meas tran vdout1_6ck450 FIND v(dout1_6) AT=460.05n

.meas tran vdout1_7ck450 FIND v(dout1_7) AT=460.05n

.meas tran vdout1_8ck450 FIND v(dout1_8) AT=460.05n

.meas tran vdout1_9ck450 FIND v(dout1_9) AT=460.05n

.meas tran vdout1_10ck450 FIND v(dout1_10) AT=460.05n

.meas tran vdout1_11ck450 FIND v(dout1_11) AT=460.05n

.meas tran vdout1_12ck450 FIND v(dout1_12) AT=460.05n

.meas tran vdout1_13ck450 FIND v(dout1_13) AT=460.05n

.meas tran vdout1_14ck450 FIND v(dout1_14) AT=460.05n

.meas tran vdout1_15ck450 FIND v(dout1_15) AT=460.05n

.meas tran vdout1_16ck450 FIND v(dout1_16) AT=460.05n

.meas tran vdout1_17ck450 FIND v(dout1_17) AT=460.05n

.meas tran vdout1_18ck450 FIND v(dout1_18) AT=460.05n

.meas tran vdout1_0ck470 FIND v(dout1_0) AT=480.05n

.meas tran vdout1_1ck470 FIND v(dout1_1) AT=480.05n

.meas tran vdout1_2ck470 FIND v(dout1_2) AT=480.05n

.meas tran vdout1_3ck470 FIND v(dout1_3) AT=480.05n

.meas tran vdout1_4ck470 FIND v(dout1_4) AT=480.05n

.meas tran vdout1_5ck470 FIND v(dout1_5) AT=480.05n

.meas tran vdout1_6ck470 FIND v(dout1_6) AT=480.05n

.meas tran vdout1_7ck470 FIND v(dout1_7) AT=480.05n

.meas tran vdout1_8ck470 FIND v(dout1_8) AT=480.05n

.meas tran vdout1_9ck470 FIND v(dout1_9) AT=480.05n

.meas tran vdout1_10ck470 FIND v(dout1_10) AT=480.05n

.meas tran vdout1_11ck470 FIND v(dout1_11) AT=480.05n

.meas tran vdout1_12ck470 FIND v(dout1_12) AT=480.05n

.meas tran vdout1_13ck470 FIND v(dout1_13) AT=480.05n

.meas tran vdout1_14ck470 FIND v(dout1_14) AT=480.05n

.meas tran vdout1_15ck470 FIND v(dout1_15) AT=480.05n

.meas tran vdout1_16ck470 FIND v(dout1_16) AT=480.05n

.meas tran vdout1_17ck470 FIND v(dout1_17) AT=480.05n

.meas tran vdout1_18ck470 FIND v(dout1_18) AT=480.05n

.meas tran vdout1_0ck490 FIND v(dout1_0) AT=500.05n

.meas tran vdout1_1ck490 FIND v(dout1_1) AT=500.05n

.meas tran vdout1_2ck490 FIND v(dout1_2) AT=500.05n

.meas tran vdout1_3ck490 FIND v(dout1_3) AT=500.05n

.meas tran vdout1_4ck490 FIND v(dout1_4) AT=500.05n

.meas tran vdout1_5ck490 FIND v(dout1_5) AT=500.05n

.meas tran vdout1_6ck490 FIND v(dout1_6) AT=500.05n

.meas tran vdout1_7ck490 FIND v(dout1_7) AT=500.05n

.meas tran vdout1_8ck490 FIND v(dout1_8) AT=500.05n

.meas tran vdout1_9ck490 FIND v(dout1_9) AT=500.05n

.meas tran vdout1_10ck490 FIND v(dout1_10) AT=500.05n

.meas tran vdout1_11ck490 FIND v(dout1_11) AT=500.05n

.meas tran vdout1_12ck490 FIND v(dout1_12) AT=500.05n

.meas tran vdout1_13ck490 FIND v(dout1_13) AT=500.05n

.meas tran vdout1_14ck490 FIND v(dout1_14) AT=500.05n

.meas tran vdout1_15ck490 FIND v(dout1_15) AT=500.05n

.meas tran vdout1_16ck490 FIND v(dout1_16) AT=500.05n

.meas tran vdout1_17ck490 FIND v(dout1_17) AT=500.05n

.meas tran vdout1_18ck490 FIND v(dout1_18) AT=500.05n

.meas tran vdout1_0ck550 FIND v(dout1_0) AT=560.05n

.meas tran vdout1_1ck550 FIND v(dout1_1) AT=560.05n

.meas tran vdout1_2ck550 FIND v(dout1_2) AT=560.05n

.meas tran vdout1_3ck550 FIND v(dout1_3) AT=560.05n

.meas tran vdout1_4ck550 FIND v(dout1_4) AT=560.05n

.meas tran vdout1_5ck550 FIND v(dout1_5) AT=560.05n

.meas tran vdout1_6ck550 FIND v(dout1_6) AT=560.05n

.meas tran vdout1_7ck550 FIND v(dout1_7) AT=560.05n

.meas tran vdout1_8ck550 FIND v(dout1_8) AT=560.05n

.meas tran vdout1_9ck550 FIND v(dout1_9) AT=560.05n

.meas tran vdout1_10ck550 FIND v(dout1_10) AT=560.05n

.meas tran vdout1_11ck550 FIND v(dout1_11) AT=560.05n

.meas tran vdout1_12ck550 FIND v(dout1_12) AT=560.05n

.meas tran vdout1_13ck550 FIND v(dout1_13) AT=560.05n

.meas tran vdout1_14ck550 FIND v(dout1_14) AT=560.05n

.meas tran vdout1_15ck550 FIND v(dout1_15) AT=560.05n

.meas tran vdout1_16ck550 FIND v(dout1_16) AT=560.05n

.meas tran vdout1_17ck550 FIND v(dout1_17) AT=560.05n

.meas tran vdout1_18ck550 FIND v(dout1_18) AT=560.05n

.meas tran vdout1_0ck570 FIND v(dout1_0) AT=580.05n

.meas tran vdout1_1ck570 FIND v(dout1_1) AT=580.05n

.meas tran vdout1_2ck570 FIND v(dout1_2) AT=580.05n

.meas tran vdout1_3ck570 FIND v(dout1_3) AT=580.05n

.meas tran vdout1_4ck570 FIND v(dout1_4) AT=580.05n

.meas tran vdout1_5ck570 FIND v(dout1_5) AT=580.05n

.meas tran vdout1_6ck570 FIND v(dout1_6) AT=580.05n

.meas tran vdout1_7ck570 FIND v(dout1_7) AT=580.05n

.meas tran vdout1_8ck570 FIND v(dout1_8) AT=580.05n

.meas tran vdout1_9ck570 FIND v(dout1_9) AT=580.05n

.meas tran vdout1_10ck570 FIND v(dout1_10) AT=580.05n

.meas tran vdout1_11ck570 FIND v(dout1_11) AT=580.05n

.meas tran vdout1_12ck570 FIND v(dout1_12) AT=580.05n

.meas tran vdout1_13ck570 FIND v(dout1_13) AT=580.05n

.meas tran vdout1_14ck570 FIND v(dout1_14) AT=580.05n

.meas tran vdout1_15ck570 FIND v(dout1_15) AT=580.05n

.meas tran vdout1_16ck570 FIND v(dout1_16) AT=580.05n

.meas tran vdout1_17ck570 FIND v(dout1_17) AT=580.05n

.meas tran vdout1_18ck570 FIND v(dout1_18) AT=580.05n

.meas tran vdout1_0ck580 FIND v(dout1_0) AT=590.05n

.meas tran vdout1_1ck580 FIND v(dout1_1) AT=590.05n

.meas tran vdout1_2ck580 FIND v(dout1_2) AT=590.05n

.meas tran vdout1_3ck580 FIND v(dout1_3) AT=590.05n

.meas tran vdout1_4ck580 FIND v(dout1_4) AT=590.05n

.meas tran vdout1_5ck580 FIND v(dout1_5) AT=590.05n

.meas tran vdout1_6ck580 FIND v(dout1_6) AT=590.05n

.meas tran vdout1_7ck580 FIND v(dout1_7) AT=590.05n

.meas tran vdout1_8ck580 FIND v(dout1_8) AT=590.05n

.meas tran vdout1_9ck580 FIND v(dout1_9) AT=590.05n

.meas tran vdout1_10ck580 FIND v(dout1_10) AT=590.05n

.meas tran vdout1_11ck580 FIND v(dout1_11) AT=590.05n

.meas tran vdout1_12ck580 FIND v(dout1_12) AT=590.05n

.meas tran vdout1_13ck580 FIND v(dout1_13) AT=590.05n

.meas tran vdout1_14ck580 FIND v(dout1_14) AT=590.05n

.meas tran vdout1_15ck580 FIND v(dout1_15) AT=590.05n

.meas tran vdout1_16ck580 FIND v(dout1_16) AT=590.05n

.meas tran vdout1_17ck580 FIND v(dout1_17) AT=590.05n

.meas tran vdout1_18ck580 FIND v(dout1_18) AT=590.05n

.meas tran vdout1_0ck660 FIND v(dout1_0) AT=670.05n

.meas tran vdout1_1ck660 FIND v(dout1_1) AT=670.05n

.meas tran vdout1_2ck660 FIND v(dout1_2) AT=670.05n

.meas tran vdout1_3ck660 FIND v(dout1_3) AT=670.05n

.meas tran vdout1_4ck660 FIND v(dout1_4) AT=670.05n

.meas tran vdout1_5ck660 FIND v(dout1_5) AT=670.05n

.meas tran vdout1_6ck660 FIND v(dout1_6) AT=670.05n

.meas tran vdout1_7ck660 FIND v(dout1_7) AT=670.05n

.meas tran vdout1_8ck660 FIND v(dout1_8) AT=670.05n

.meas tran vdout1_9ck660 FIND v(dout1_9) AT=670.05n

.meas tran vdout1_10ck660 FIND v(dout1_10) AT=670.05n

.meas tran vdout1_11ck660 FIND v(dout1_11) AT=670.05n

.meas tran vdout1_12ck660 FIND v(dout1_12) AT=670.05n

.meas tran vdout1_13ck660 FIND v(dout1_13) AT=670.05n

.meas tran vdout1_14ck660 FIND v(dout1_14) AT=670.05n

.meas tran vdout1_15ck660 FIND v(dout1_15) AT=670.05n

.meas tran vdout1_16ck660 FIND v(dout1_16) AT=670.05n

.meas tran vdout1_17ck660 FIND v(dout1_17) AT=670.05n

.meas tran vdout1_18ck660 FIND v(dout1_18) AT=670.05n

.meas tran vdout1_0ck740 FIND v(dout1_0) AT=750.05n

.meas tran vdout1_1ck740 FIND v(dout1_1) AT=750.05n

.meas tran vdout1_2ck740 FIND v(dout1_2) AT=750.05n

.meas tran vdout1_3ck740 FIND v(dout1_3) AT=750.05n

.meas tran vdout1_4ck740 FIND v(dout1_4) AT=750.05n

.meas tran vdout1_5ck740 FIND v(dout1_5) AT=750.05n

.meas tran vdout1_6ck740 FIND v(dout1_6) AT=750.05n

.meas tran vdout1_7ck740 FIND v(dout1_7) AT=750.05n

.meas tran vdout1_8ck740 FIND v(dout1_8) AT=750.05n

.meas tran vdout1_9ck740 FIND v(dout1_9) AT=750.05n

.meas tran vdout1_10ck740 FIND v(dout1_10) AT=750.05n

.meas tran vdout1_11ck740 FIND v(dout1_11) AT=750.05n

.meas tran vdout1_12ck740 FIND v(dout1_12) AT=750.05n

.meas tran vdout1_13ck740 FIND v(dout1_13) AT=750.05n

.meas tran vdout1_14ck740 FIND v(dout1_14) AT=750.05n

.meas tran vdout1_15ck740 FIND v(dout1_15) AT=750.05n

.meas tran vdout1_16ck740 FIND v(dout1_16) AT=750.05n

.meas tran vdout1_17ck740 FIND v(dout1_17) AT=750.05n

.meas tran vdout1_18ck740 FIND v(dout1_18) AT=750.05n

.meas tran vdout1_0ck750 FIND v(dout1_0) AT=760.05n

.meas tran vdout1_1ck750 FIND v(dout1_1) AT=760.05n

.meas tran vdout1_2ck750 FIND v(dout1_2) AT=760.05n

.meas tran vdout1_3ck750 FIND v(dout1_3) AT=760.05n

.meas tran vdout1_4ck750 FIND v(dout1_4) AT=760.05n

.meas tran vdout1_5ck750 FIND v(dout1_5) AT=760.05n

.meas tran vdout1_6ck750 FIND v(dout1_6) AT=760.05n

.meas tran vdout1_7ck750 FIND v(dout1_7) AT=760.05n

.meas tran vdout1_8ck750 FIND v(dout1_8) AT=760.05n

.meas tran vdout1_9ck750 FIND v(dout1_9) AT=760.05n

.meas tran vdout1_10ck750 FIND v(dout1_10) AT=760.05n

.meas tran vdout1_11ck750 FIND v(dout1_11) AT=760.05n

.meas tran vdout1_12ck750 FIND v(dout1_12) AT=760.05n

.meas tran vdout1_13ck750 FIND v(dout1_13) AT=760.05n

.meas tran vdout1_14ck750 FIND v(dout1_14) AT=760.05n

.meas tran vdout1_15ck750 FIND v(dout1_15) AT=760.05n

.meas tran vdout1_16ck750 FIND v(dout1_16) AT=760.05n

.meas tran vdout1_17ck750 FIND v(dout1_17) AT=760.05n

.meas tran vdout1_18ck750 FIND v(dout1_18) AT=760.05n

.meas tran vdout1_0ck760 FIND v(dout1_0) AT=770.05n

.meas tran vdout1_1ck760 FIND v(dout1_1) AT=770.05n

.meas tran vdout1_2ck760 FIND v(dout1_2) AT=770.05n

.meas tran vdout1_3ck760 FIND v(dout1_3) AT=770.05n

.meas tran vdout1_4ck760 FIND v(dout1_4) AT=770.05n

.meas tran vdout1_5ck760 FIND v(dout1_5) AT=770.05n

.meas tran vdout1_6ck760 FIND v(dout1_6) AT=770.05n

.meas tran vdout1_7ck760 FIND v(dout1_7) AT=770.05n

.meas tran vdout1_8ck760 FIND v(dout1_8) AT=770.05n

.meas tran vdout1_9ck760 FIND v(dout1_9) AT=770.05n

.meas tran vdout1_10ck760 FIND v(dout1_10) AT=770.05n

.meas tran vdout1_11ck760 FIND v(dout1_11) AT=770.05n

.meas tran vdout1_12ck760 FIND v(dout1_12) AT=770.05n

.meas tran vdout1_13ck760 FIND v(dout1_13) AT=770.05n

.meas tran vdout1_14ck760 FIND v(dout1_14) AT=770.05n

.meas tran vdout1_15ck760 FIND v(dout1_15) AT=770.05n

.meas tran vdout1_16ck760 FIND v(dout1_16) AT=770.05n

.meas tran vdout1_17ck760 FIND v(dout1_17) AT=770.05n

.meas tran vdout1_18ck760 FIND v(dout1_18) AT=770.05n

.meas tran vdout1_0ck770 FIND v(dout1_0) AT=780.05n

.meas tran vdout1_1ck770 FIND v(dout1_1) AT=780.05n

.meas tran vdout1_2ck770 FIND v(dout1_2) AT=780.05n

.meas tran vdout1_3ck770 FIND v(dout1_3) AT=780.05n

.meas tran vdout1_4ck770 FIND v(dout1_4) AT=780.05n

.meas tran vdout1_5ck770 FIND v(dout1_5) AT=780.05n

.meas tran vdout1_6ck770 FIND v(dout1_6) AT=780.05n

.meas tran vdout1_7ck770 FIND v(dout1_7) AT=780.05n

.meas tran vdout1_8ck770 FIND v(dout1_8) AT=780.05n

.meas tran vdout1_9ck770 FIND v(dout1_9) AT=780.05n

.meas tran vdout1_10ck770 FIND v(dout1_10) AT=780.05n

.meas tran vdout1_11ck770 FIND v(dout1_11) AT=780.05n

.meas tran vdout1_12ck770 FIND v(dout1_12) AT=780.05n

.meas tran vdout1_13ck770 FIND v(dout1_13) AT=780.05n

.meas tran vdout1_14ck770 FIND v(dout1_14) AT=780.05n

.meas tran vdout1_15ck770 FIND v(dout1_15) AT=780.05n

.meas tran vdout1_16ck770 FIND v(dout1_16) AT=780.05n

.meas tran vdout1_17ck770 FIND v(dout1_17) AT=780.05n

.meas tran vdout1_18ck770 FIND v(dout1_18) AT=780.05n

.meas tran vdout1_0ck800 FIND v(dout1_0) AT=810.05n

.meas tran vdout1_1ck800 FIND v(dout1_1) AT=810.05n

.meas tran vdout1_2ck800 FIND v(dout1_2) AT=810.05n

.meas tran vdout1_3ck800 FIND v(dout1_3) AT=810.05n

.meas tran vdout1_4ck800 FIND v(dout1_4) AT=810.05n

.meas tran vdout1_5ck800 FIND v(dout1_5) AT=810.05n

.meas tran vdout1_6ck800 FIND v(dout1_6) AT=810.05n

.meas tran vdout1_7ck800 FIND v(dout1_7) AT=810.05n

.meas tran vdout1_8ck800 FIND v(dout1_8) AT=810.05n

.meas tran vdout1_9ck800 FIND v(dout1_9) AT=810.05n

.meas tran vdout1_10ck800 FIND v(dout1_10) AT=810.05n

.meas tran vdout1_11ck800 FIND v(dout1_11) AT=810.05n

.meas tran vdout1_12ck800 FIND v(dout1_12) AT=810.05n

.meas tran vdout1_13ck800 FIND v(dout1_13) AT=810.05n

.meas tran vdout1_14ck800 FIND v(dout1_14) AT=810.05n

.meas tran vdout1_15ck800 FIND v(dout1_15) AT=810.05n

.meas tran vdout1_16ck800 FIND v(dout1_16) AT=810.05n

.meas tran vdout1_17ck800 FIND v(dout1_17) AT=810.05n

.meas tran vdout1_18ck800 FIND v(dout1_18) AT=810.05n

.meas tran vdout1_0ck820 FIND v(dout1_0) AT=830.05n

.meas tran vdout1_1ck820 FIND v(dout1_1) AT=830.05n

.meas tran vdout1_2ck820 FIND v(dout1_2) AT=830.05n

.meas tran vdout1_3ck820 FIND v(dout1_3) AT=830.05n

.meas tran vdout1_4ck820 FIND v(dout1_4) AT=830.05n

.meas tran vdout1_5ck820 FIND v(dout1_5) AT=830.05n

.meas tran vdout1_6ck820 FIND v(dout1_6) AT=830.05n

.meas tran vdout1_7ck820 FIND v(dout1_7) AT=830.05n

.meas tran vdout1_8ck820 FIND v(dout1_8) AT=830.05n

.meas tran vdout1_9ck820 FIND v(dout1_9) AT=830.05n

.meas tran vdout1_10ck820 FIND v(dout1_10) AT=830.05n

.meas tran vdout1_11ck820 FIND v(dout1_11) AT=830.05n

.meas tran vdout1_12ck820 FIND v(dout1_12) AT=830.05n

.meas tran vdout1_13ck820 FIND v(dout1_13) AT=830.05n

.meas tran vdout1_14ck820 FIND v(dout1_14) AT=830.05n

.meas tran vdout1_15ck820 FIND v(dout1_15) AT=830.05n

.meas tran vdout1_16ck820 FIND v(dout1_16) AT=830.05n

.meas tran vdout1_17ck820 FIND v(dout1_17) AT=830.05n

.meas tran vdout1_18ck820 FIND v(dout1_18) AT=830.05n

.meas tran vdout1_0ck840 FIND v(dout1_0) AT=850.05n

.meas tran vdout1_1ck840 FIND v(dout1_1) AT=850.05n

.meas tran vdout1_2ck840 FIND v(dout1_2) AT=850.05n

.meas tran vdout1_3ck840 FIND v(dout1_3) AT=850.05n

.meas tran vdout1_4ck840 FIND v(dout1_4) AT=850.05n

.meas tran vdout1_5ck840 FIND v(dout1_5) AT=850.05n

.meas tran vdout1_6ck840 FIND v(dout1_6) AT=850.05n

.meas tran vdout1_7ck840 FIND v(dout1_7) AT=850.05n

.meas tran vdout1_8ck840 FIND v(dout1_8) AT=850.05n

.meas tran vdout1_9ck840 FIND v(dout1_9) AT=850.05n

.meas tran vdout1_10ck840 FIND v(dout1_10) AT=850.05n

.meas tran vdout1_11ck840 FIND v(dout1_11) AT=850.05n

.meas tran vdout1_12ck840 FIND v(dout1_12) AT=850.05n

.meas tran vdout1_13ck840 FIND v(dout1_13) AT=850.05n

.meas tran vdout1_14ck840 FIND v(dout1_14) AT=850.05n

.meas tran vdout1_15ck840 FIND v(dout1_15) AT=850.05n

.meas tran vdout1_16ck840 FIND v(dout1_16) AT=850.05n

.meas tran vdout1_17ck840 FIND v(dout1_17) AT=850.05n

.meas tran vdout1_18ck840 FIND v(dout1_18) AT=850.05n

.meas tran vdout1_0ck850 FIND v(dout1_0) AT=860.05n

.meas tran vdout1_1ck850 FIND v(dout1_1) AT=860.05n

.meas tran vdout1_2ck850 FIND v(dout1_2) AT=860.05n

.meas tran vdout1_3ck850 FIND v(dout1_3) AT=860.05n

.meas tran vdout1_4ck850 FIND v(dout1_4) AT=860.05n

.meas tran vdout1_5ck850 FIND v(dout1_5) AT=860.05n

.meas tran vdout1_6ck850 FIND v(dout1_6) AT=860.05n

.meas tran vdout1_7ck850 FIND v(dout1_7) AT=860.05n

.meas tran vdout1_8ck850 FIND v(dout1_8) AT=860.05n

.meas tran vdout1_9ck850 FIND v(dout1_9) AT=860.05n

.meas tran vdout1_10ck850 FIND v(dout1_10) AT=860.05n

.meas tran vdout1_11ck850 FIND v(dout1_11) AT=860.05n

.meas tran vdout1_12ck850 FIND v(dout1_12) AT=860.05n

.meas tran vdout1_13ck850 FIND v(dout1_13) AT=860.05n

.meas tran vdout1_14ck850 FIND v(dout1_14) AT=860.05n

.meas tran vdout1_15ck850 FIND v(dout1_15) AT=860.05n

.meas tran vdout1_16ck850 FIND v(dout1_16) AT=860.05n

.meas tran vdout1_17ck850 FIND v(dout1_17) AT=860.05n

.meas tran vdout1_18ck850 FIND v(dout1_18) AT=860.05n

.meas tran vdout1_0ck930 FIND v(dout1_0) AT=940.05n

.meas tran vdout1_1ck930 FIND v(dout1_1) AT=940.05n

.meas tran vdout1_2ck930 FIND v(dout1_2) AT=940.05n

.meas tran vdout1_3ck930 FIND v(dout1_3) AT=940.05n

.meas tran vdout1_4ck930 FIND v(dout1_4) AT=940.05n

.meas tran vdout1_5ck930 FIND v(dout1_5) AT=940.05n

.meas tran vdout1_6ck930 FIND v(dout1_6) AT=940.05n

.meas tran vdout1_7ck930 FIND v(dout1_7) AT=940.05n

.meas tran vdout1_8ck930 FIND v(dout1_8) AT=940.05n

.meas tran vdout1_9ck930 FIND v(dout1_9) AT=940.05n

.meas tran vdout1_10ck930 FIND v(dout1_10) AT=940.05n

.meas tran vdout1_11ck930 FIND v(dout1_11) AT=940.05n

.meas tran vdout1_12ck930 FIND v(dout1_12) AT=940.05n

.meas tran vdout1_13ck930 FIND v(dout1_13) AT=940.05n

.meas tran vdout1_14ck930 FIND v(dout1_14) AT=940.05n

.meas tran vdout1_15ck930 FIND v(dout1_15) AT=940.05n

.meas tran vdout1_16ck930 FIND v(dout1_16) AT=940.05n

.meas tran vdout1_17ck930 FIND v(dout1_17) AT=940.05n

.meas tran vdout1_18ck930 FIND v(dout1_18) AT=940.05n

.meas tran vdout1_0ck960 FIND v(dout1_0) AT=970.05n

.meas tran vdout1_1ck960 FIND v(dout1_1) AT=970.05n

.meas tran vdout1_2ck960 FIND v(dout1_2) AT=970.05n

.meas tran vdout1_3ck960 FIND v(dout1_3) AT=970.05n

.meas tran vdout1_4ck960 FIND v(dout1_4) AT=970.05n

.meas tran vdout1_5ck960 FIND v(dout1_5) AT=970.05n

.meas tran vdout1_6ck960 FIND v(dout1_6) AT=970.05n

.meas tran vdout1_7ck960 FIND v(dout1_7) AT=970.05n

.meas tran vdout1_8ck960 FIND v(dout1_8) AT=970.05n

.meas tran vdout1_9ck960 FIND v(dout1_9) AT=970.05n

.meas tran vdout1_10ck960 FIND v(dout1_10) AT=970.05n

.meas tran vdout1_11ck960 FIND v(dout1_11) AT=970.05n

.meas tran vdout1_12ck960 FIND v(dout1_12) AT=970.05n

.meas tran vdout1_13ck960 FIND v(dout1_13) AT=970.05n

.meas tran vdout1_14ck960 FIND v(dout1_14) AT=970.05n

.meas tran vdout1_15ck960 FIND v(dout1_15) AT=970.05n

.meas tran vdout1_16ck960 FIND v(dout1_16) AT=970.05n

.meas tran vdout1_17ck960 FIND v(dout1_17) AT=970.05n

.meas tran vdout1_18ck960 FIND v(dout1_18) AT=970.05n

.meas tran vdout1_0ck1030 FIND v(dout1_0) AT=1040.05n

.meas tran vdout1_1ck1030 FIND v(dout1_1) AT=1040.05n

.meas tran vdout1_2ck1030 FIND v(dout1_2) AT=1040.05n

.meas tran vdout1_3ck1030 FIND v(dout1_3) AT=1040.05n

.meas tran vdout1_4ck1030 FIND v(dout1_4) AT=1040.05n

.meas tran vdout1_5ck1030 FIND v(dout1_5) AT=1040.05n

.meas tran vdout1_6ck1030 FIND v(dout1_6) AT=1040.05n

.meas tran vdout1_7ck1030 FIND v(dout1_7) AT=1040.05n

.meas tran vdout1_8ck1030 FIND v(dout1_8) AT=1040.05n

.meas tran vdout1_9ck1030 FIND v(dout1_9) AT=1040.05n

.meas tran vdout1_10ck1030 FIND v(dout1_10) AT=1040.05n

.meas tran vdout1_11ck1030 FIND v(dout1_11) AT=1040.05n

.meas tran vdout1_12ck1030 FIND v(dout1_12) AT=1040.05n

.meas tran vdout1_13ck1030 FIND v(dout1_13) AT=1040.05n

.meas tran vdout1_14ck1030 FIND v(dout1_14) AT=1040.05n

.meas tran vdout1_15ck1030 FIND v(dout1_15) AT=1040.05n

.meas tran vdout1_16ck1030 FIND v(dout1_16) AT=1040.05n

.meas tran vdout1_17ck1030 FIND v(dout1_17) AT=1040.05n

.meas tran vdout1_18ck1030 FIND v(dout1_18) AT=1040.05n

.meas tran vdout1_0ck1040 FIND v(dout1_0) AT=1050.05n

.meas tran vdout1_1ck1040 FIND v(dout1_1) AT=1050.05n

.meas tran vdout1_2ck1040 FIND v(dout1_2) AT=1050.05n

.meas tran vdout1_3ck1040 FIND v(dout1_3) AT=1050.05n

.meas tran vdout1_4ck1040 FIND v(dout1_4) AT=1050.05n

.meas tran vdout1_5ck1040 FIND v(dout1_5) AT=1050.05n

.meas tran vdout1_6ck1040 FIND v(dout1_6) AT=1050.05n

.meas tran vdout1_7ck1040 FIND v(dout1_7) AT=1050.05n

.meas tran vdout1_8ck1040 FIND v(dout1_8) AT=1050.05n

.meas tran vdout1_9ck1040 FIND v(dout1_9) AT=1050.05n

.meas tran vdout1_10ck1040 FIND v(dout1_10) AT=1050.05n

.meas tran vdout1_11ck1040 FIND v(dout1_11) AT=1050.05n

.meas tran vdout1_12ck1040 FIND v(dout1_12) AT=1050.05n

.meas tran vdout1_13ck1040 FIND v(dout1_13) AT=1050.05n

.meas tran vdout1_14ck1040 FIND v(dout1_14) AT=1050.05n

.meas tran vdout1_15ck1040 FIND v(dout1_15) AT=1050.05n

.meas tran vdout1_16ck1040 FIND v(dout1_16) AT=1050.05n

.meas tran vdout1_17ck1040 FIND v(dout1_17) AT=1050.05n

.meas tran vdout1_18ck1040 FIND v(dout1_18) AT=1050.05n

.meas tran vdout1_0ck1170 FIND v(dout1_0) AT=1180.05n

.meas tran vdout1_1ck1170 FIND v(dout1_1) AT=1180.05n

.meas tran vdout1_2ck1170 FIND v(dout1_2) AT=1180.05n

.meas tran vdout1_3ck1170 FIND v(dout1_3) AT=1180.05n

.meas tran vdout1_4ck1170 FIND v(dout1_4) AT=1180.05n

.meas tran vdout1_5ck1170 FIND v(dout1_5) AT=1180.05n

.meas tran vdout1_6ck1170 FIND v(dout1_6) AT=1180.05n

.meas tran vdout1_7ck1170 FIND v(dout1_7) AT=1180.05n

.meas tran vdout1_8ck1170 FIND v(dout1_8) AT=1180.05n

.meas tran vdout1_9ck1170 FIND v(dout1_9) AT=1180.05n

.meas tran vdout1_10ck1170 FIND v(dout1_10) AT=1180.05n

.meas tran vdout1_11ck1170 FIND v(dout1_11) AT=1180.05n

.meas tran vdout1_12ck1170 FIND v(dout1_12) AT=1180.05n

.meas tran vdout1_13ck1170 FIND v(dout1_13) AT=1180.05n

.meas tran vdout1_14ck1170 FIND v(dout1_14) AT=1180.05n

.meas tran vdout1_15ck1170 FIND v(dout1_15) AT=1180.05n

.meas tran vdout1_16ck1170 FIND v(dout1_16) AT=1180.05n

.meas tran vdout1_17ck1170 FIND v(dout1_17) AT=1180.05n

.meas tran vdout1_18ck1170 FIND v(dout1_18) AT=1180.05n

.meas tran vdout1_0ck1180 FIND v(dout1_0) AT=1190.05n

.meas tran vdout1_1ck1180 FIND v(dout1_1) AT=1190.05n

.meas tran vdout1_2ck1180 FIND v(dout1_2) AT=1190.05n

.meas tran vdout1_3ck1180 FIND v(dout1_3) AT=1190.05n

.meas tran vdout1_4ck1180 FIND v(dout1_4) AT=1190.05n

.meas tran vdout1_5ck1180 FIND v(dout1_5) AT=1190.05n

.meas tran vdout1_6ck1180 FIND v(dout1_6) AT=1190.05n

.meas tran vdout1_7ck1180 FIND v(dout1_7) AT=1190.05n

.meas tran vdout1_8ck1180 FIND v(dout1_8) AT=1190.05n

.meas tran vdout1_9ck1180 FIND v(dout1_9) AT=1190.05n

.meas tran vdout1_10ck1180 FIND v(dout1_10) AT=1190.05n

.meas tran vdout1_11ck1180 FIND v(dout1_11) AT=1190.05n

.meas tran vdout1_12ck1180 FIND v(dout1_12) AT=1190.05n

.meas tran vdout1_13ck1180 FIND v(dout1_13) AT=1190.05n

.meas tran vdout1_14ck1180 FIND v(dout1_14) AT=1190.05n

.meas tran vdout1_15ck1180 FIND v(dout1_15) AT=1190.05n

.meas tran vdout1_16ck1180 FIND v(dout1_16) AT=1190.05n

.meas tran vdout1_17ck1180 FIND v(dout1_17) AT=1190.05n

.meas tran vdout1_18ck1180 FIND v(dout1_18) AT=1190.05n

.meas tran vdout1_0ck1200 FIND v(dout1_0) AT=1210.05n

.meas tran vdout1_1ck1200 FIND v(dout1_1) AT=1210.05n

.meas tran vdout1_2ck1200 FIND v(dout1_2) AT=1210.05n

.meas tran vdout1_3ck1200 FIND v(dout1_3) AT=1210.05n

.meas tran vdout1_4ck1200 FIND v(dout1_4) AT=1210.05n

.meas tran vdout1_5ck1200 FIND v(dout1_5) AT=1210.05n

.meas tran vdout1_6ck1200 FIND v(dout1_6) AT=1210.05n

.meas tran vdout1_7ck1200 FIND v(dout1_7) AT=1210.05n

.meas tran vdout1_8ck1200 FIND v(dout1_8) AT=1210.05n

.meas tran vdout1_9ck1200 FIND v(dout1_9) AT=1210.05n

.meas tran vdout1_10ck1200 FIND v(dout1_10) AT=1210.05n

.meas tran vdout1_11ck1200 FIND v(dout1_11) AT=1210.05n

.meas tran vdout1_12ck1200 FIND v(dout1_12) AT=1210.05n

.meas tran vdout1_13ck1200 FIND v(dout1_13) AT=1210.05n

.meas tran vdout1_14ck1200 FIND v(dout1_14) AT=1210.05n

.meas tran vdout1_15ck1200 FIND v(dout1_15) AT=1210.05n

.meas tran vdout1_16ck1200 FIND v(dout1_16) AT=1210.05n

.meas tran vdout1_17ck1200 FIND v(dout1_17) AT=1210.05n

.meas tran vdout1_18ck1200 FIND v(dout1_18) AT=1210.05n

.meas tran vdout1_0ck1240 FIND v(dout1_0) AT=1250.05n

.meas tran vdout1_1ck1240 FIND v(dout1_1) AT=1250.05n

.meas tran vdout1_2ck1240 FIND v(dout1_2) AT=1250.05n

.meas tran vdout1_3ck1240 FIND v(dout1_3) AT=1250.05n

.meas tran vdout1_4ck1240 FIND v(dout1_4) AT=1250.05n

.meas tran vdout1_5ck1240 FIND v(dout1_5) AT=1250.05n

.meas tran vdout1_6ck1240 FIND v(dout1_6) AT=1250.05n

.meas tran vdout1_7ck1240 FIND v(dout1_7) AT=1250.05n

.meas tran vdout1_8ck1240 FIND v(dout1_8) AT=1250.05n

.meas tran vdout1_9ck1240 FIND v(dout1_9) AT=1250.05n

.meas tran vdout1_10ck1240 FIND v(dout1_10) AT=1250.05n

.meas tran vdout1_11ck1240 FIND v(dout1_11) AT=1250.05n

.meas tran vdout1_12ck1240 FIND v(dout1_12) AT=1250.05n

.meas tran vdout1_13ck1240 FIND v(dout1_13) AT=1250.05n

.meas tran vdout1_14ck1240 FIND v(dout1_14) AT=1250.05n

.meas tran vdout1_15ck1240 FIND v(dout1_15) AT=1250.05n

.meas tran vdout1_16ck1240 FIND v(dout1_16) AT=1250.05n

.meas tran vdout1_17ck1240 FIND v(dout1_17) AT=1250.05n

.meas tran vdout1_18ck1240 FIND v(dout1_18) AT=1250.05n

.meas tran vdout1_0ck1250 FIND v(dout1_0) AT=1260.05n

.meas tran vdout1_1ck1250 FIND v(dout1_1) AT=1260.05n

.meas tran vdout1_2ck1250 FIND v(dout1_2) AT=1260.05n

.meas tran vdout1_3ck1250 FIND v(dout1_3) AT=1260.05n

.meas tran vdout1_4ck1250 FIND v(dout1_4) AT=1260.05n

.meas tran vdout1_5ck1250 FIND v(dout1_5) AT=1260.05n

.meas tran vdout1_6ck1250 FIND v(dout1_6) AT=1260.05n

.meas tran vdout1_7ck1250 FIND v(dout1_7) AT=1260.05n

.meas tran vdout1_8ck1250 FIND v(dout1_8) AT=1260.05n

.meas tran vdout1_9ck1250 FIND v(dout1_9) AT=1260.05n

.meas tran vdout1_10ck1250 FIND v(dout1_10) AT=1260.05n

.meas tran vdout1_11ck1250 FIND v(dout1_11) AT=1260.05n

.meas tran vdout1_12ck1250 FIND v(dout1_12) AT=1260.05n

.meas tran vdout1_13ck1250 FIND v(dout1_13) AT=1260.05n

.meas tran vdout1_14ck1250 FIND v(dout1_14) AT=1260.05n

.meas tran vdout1_15ck1250 FIND v(dout1_15) AT=1260.05n

.meas tran vdout1_16ck1250 FIND v(dout1_16) AT=1260.05n

.meas tran vdout1_17ck1250 FIND v(dout1_17) AT=1260.05n

.meas tran vdout1_18ck1250 FIND v(dout1_18) AT=1260.05n

.meas tran vdout1_0ck1270 FIND v(dout1_0) AT=1280.05n

.meas tran vdout1_1ck1270 FIND v(dout1_1) AT=1280.05n

.meas tran vdout1_2ck1270 FIND v(dout1_2) AT=1280.05n

.meas tran vdout1_3ck1270 FIND v(dout1_3) AT=1280.05n

.meas tran vdout1_4ck1270 FIND v(dout1_4) AT=1280.05n

.meas tran vdout1_5ck1270 FIND v(dout1_5) AT=1280.05n

.meas tran vdout1_6ck1270 FIND v(dout1_6) AT=1280.05n

.meas tran vdout1_7ck1270 FIND v(dout1_7) AT=1280.05n

.meas tran vdout1_8ck1270 FIND v(dout1_8) AT=1280.05n

.meas tran vdout1_9ck1270 FIND v(dout1_9) AT=1280.05n

.meas tran vdout1_10ck1270 FIND v(dout1_10) AT=1280.05n

.meas tran vdout1_11ck1270 FIND v(dout1_11) AT=1280.05n

.meas tran vdout1_12ck1270 FIND v(dout1_12) AT=1280.05n

.meas tran vdout1_13ck1270 FIND v(dout1_13) AT=1280.05n

.meas tran vdout1_14ck1270 FIND v(dout1_14) AT=1280.05n

.meas tran vdout1_15ck1270 FIND v(dout1_15) AT=1280.05n

.meas tran vdout1_16ck1270 FIND v(dout1_16) AT=1280.05n

.meas tran vdout1_17ck1270 FIND v(dout1_17) AT=1280.05n

.meas tran vdout1_18ck1270 FIND v(dout1_18) AT=1280.05n

.meas tran vdout1_0ck1300 FIND v(dout1_0) AT=1310.05n

.meas tran vdout1_1ck1300 FIND v(dout1_1) AT=1310.05n

.meas tran vdout1_2ck1300 FIND v(dout1_2) AT=1310.05n

.meas tran vdout1_3ck1300 FIND v(dout1_3) AT=1310.05n

.meas tran vdout1_4ck1300 FIND v(dout1_4) AT=1310.05n

.meas tran vdout1_5ck1300 FIND v(dout1_5) AT=1310.05n

.meas tran vdout1_6ck1300 FIND v(dout1_6) AT=1310.05n

.meas tran vdout1_7ck1300 FIND v(dout1_7) AT=1310.05n

.meas tran vdout1_8ck1300 FIND v(dout1_8) AT=1310.05n

.meas tran vdout1_9ck1300 FIND v(dout1_9) AT=1310.05n

.meas tran vdout1_10ck1300 FIND v(dout1_10) AT=1310.05n

.meas tran vdout1_11ck1300 FIND v(dout1_11) AT=1310.05n

.meas tran vdout1_12ck1300 FIND v(dout1_12) AT=1310.05n

.meas tran vdout1_13ck1300 FIND v(dout1_13) AT=1310.05n

.meas tran vdout1_14ck1300 FIND v(dout1_14) AT=1310.05n

.meas tran vdout1_15ck1300 FIND v(dout1_15) AT=1310.05n

.meas tran vdout1_16ck1300 FIND v(dout1_16) AT=1310.05n

.meas tran vdout1_17ck1300 FIND v(dout1_17) AT=1310.05n

.meas tran vdout1_18ck1300 FIND v(dout1_18) AT=1310.05n

.meas tran vdout1_0ck1310 FIND v(dout1_0) AT=1320.05n

.meas tran vdout1_1ck1310 FIND v(dout1_1) AT=1320.05n

.meas tran vdout1_2ck1310 FIND v(dout1_2) AT=1320.05n

.meas tran vdout1_3ck1310 FIND v(dout1_3) AT=1320.05n

.meas tran vdout1_4ck1310 FIND v(dout1_4) AT=1320.05n

.meas tran vdout1_5ck1310 FIND v(dout1_5) AT=1320.05n

.meas tran vdout1_6ck1310 FIND v(dout1_6) AT=1320.05n

.meas tran vdout1_7ck1310 FIND v(dout1_7) AT=1320.05n

.meas tran vdout1_8ck1310 FIND v(dout1_8) AT=1320.05n

.meas tran vdout1_9ck1310 FIND v(dout1_9) AT=1320.05n

.meas tran vdout1_10ck1310 FIND v(dout1_10) AT=1320.05n

.meas tran vdout1_11ck1310 FIND v(dout1_11) AT=1320.05n

.meas tran vdout1_12ck1310 FIND v(dout1_12) AT=1320.05n

.meas tran vdout1_13ck1310 FIND v(dout1_13) AT=1320.05n

.meas tran vdout1_14ck1310 FIND v(dout1_14) AT=1320.05n

.meas tran vdout1_15ck1310 FIND v(dout1_15) AT=1320.05n

.meas tran vdout1_16ck1310 FIND v(dout1_16) AT=1320.05n

.meas tran vdout1_17ck1310 FIND v(dout1_17) AT=1320.05n

.meas tran vdout1_18ck1310 FIND v(dout1_18) AT=1320.05n

.meas tran vdout1_0ck1340 FIND v(dout1_0) AT=1350.05n

.meas tran vdout1_1ck1340 FIND v(dout1_1) AT=1350.05n

.meas tran vdout1_2ck1340 FIND v(dout1_2) AT=1350.05n

.meas tran vdout1_3ck1340 FIND v(dout1_3) AT=1350.05n

.meas tran vdout1_4ck1340 FIND v(dout1_4) AT=1350.05n

.meas tran vdout1_5ck1340 FIND v(dout1_5) AT=1350.05n

.meas tran vdout1_6ck1340 FIND v(dout1_6) AT=1350.05n

.meas tran vdout1_7ck1340 FIND v(dout1_7) AT=1350.05n

.meas tran vdout1_8ck1340 FIND v(dout1_8) AT=1350.05n

.meas tran vdout1_9ck1340 FIND v(dout1_9) AT=1350.05n

.meas tran vdout1_10ck1340 FIND v(dout1_10) AT=1350.05n

.meas tran vdout1_11ck1340 FIND v(dout1_11) AT=1350.05n

.meas tran vdout1_12ck1340 FIND v(dout1_12) AT=1350.05n

.meas tran vdout1_13ck1340 FIND v(dout1_13) AT=1350.05n

.meas tran vdout1_14ck1340 FIND v(dout1_14) AT=1350.05n

.meas tran vdout1_15ck1340 FIND v(dout1_15) AT=1350.05n

.meas tran vdout1_16ck1340 FIND v(dout1_16) AT=1350.05n

.meas tran vdout1_17ck1340 FIND v(dout1_17) AT=1350.05n

.meas tran vdout1_18ck1340 FIND v(dout1_18) AT=1350.05n

.meas tran vdout1_0ck1430 FIND v(dout1_0) AT=1440.05n

.meas tran vdout1_1ck1430 FIND v(dout1_1) AT=1440.05n

.meas tran vdout1_2ck1430 FIND v(dout1_2) AT=1440.05n

.meas tran vdout1_3ck1430 FIND v(dout1_3) AT=1440.05n

.meas tran vdout1_4ck1430 FIND v(dout1_4) AT=1440.05n

.meas tran vdout1_5ck1430 FIND v(dout1_5) AT=1440.05n

.meas tran vdout1_6ck1430 FIND v(dout1_6) AT=1440.05n

.meas tran vdout1_7ck1430 FIND v(dout1_7) AT=1440.05n

.meas tran vdout1_8ck1430 FIND v(dout1_8) AT=1440.05n

.meas tran vdout1_9ck1430 FIND v(dout1_9) AT=1440.05n

.meas tran vdout1_10ck1430 FIND v(dout1_10) AT=1440.05n

.meas tran vdout1_11ck1430 FIND v(dout1_11) AT=1440.05n

.meas tran vdout1_12ck1430 FIND v(dout1_12) AT=1440.05n

.meas tran vdout1_13ck1430 FIND v(dout1_13) AT=1440.05n

.meas tran vdout1_14ck1430 FIND v(dout1_14) AT=1440.05n

.meas tran vdout1_15ck1430 FIND v(dout1_15) AT=1440.05n

.meas tran vdout1_16ck1430 FIND v(dout1_16) AT=1440.05n

.meas tran vdout1_17ck1430 FIND v(dout1_17) AT=1440.05n

.meas tran vdout1_18ck1430 FIND v(dout1_18) AT=1440.05n

.meas tran vdout1_0ck1460 FIND v(dout1_0) AT=1470.05n

.meas tran vdout1_1ck1460 FIND v(dout1_1) AT=1470.05n

.meas tran vdout1_2ck1460 FIND v(dout1_2) AT=1470.05n

.meas tran vdout1_3ck1460 FIND v(dout1_3) AT=1470.05n

.meas tran vdout1_4ck1460 FIND v(dout1_4) AT=1470.05n

.meas tran vdout1_5ck1460 FIND v(dout1_5) AT=1470.05n

.meas tran vdout1_6ck1460 FIND v(dout1_6) AT=1470.05n

.meas tran vdout1_7ck1460 FIND v(dout1_7) AT=1470.05n

.meas tran vdout1_8ck1460 FIND v(dout1_8) AT=1470.05n

.meas tran vdout1_9ck1460 FIND v(dout1_9) AT=1470.05n

.meas tran vdout1_10ck1460 FIND v(dout1_10) AT=1470.05n

.meas tran vdout1_11ck1460 FIND v(dout1_11) AT=1470.05n

.meas tran vdout1_12ck1460 FIND v(dout1_12) AT=1470.05n

.meas tran vdout1_13ck1460 FIND v(dout1_13) AT=1470.05n

.meas tran vdout1_14ck1460 FIND v(dout1_14) AT=1470.05n

.meas tran vdout1_15ck1460 FIND v(dout1_15) AT=1470.05n

.meas tran vdout1_16ck1460 FIND v(dout1_16) AT=1470.05n

.meas tran vdout1_17ck1460 FIND v(dout1_17) AT=1470.05n

.meas tran vdout1_18ck1460 FIND v(dout1_18) AT=1470.05n

.meas tran vdout1_0ck1470 FIND v(dout1_0) AT=1480.05n

.meas tran vdout1_1ck1470 FIND v(dout1_1) AT=1480.05n

.meas tran vdout1_2ck1470 FIND v(dout1_2) AT=1480.05n

.meas tran vdout1_3ck1470 FIND v(dout1_3) AT=1480.05n

.meas tran vdout1_4ck1470 FIND v(dout1_4) AT=1480.05n

.meas tran vdout1_5ck1470 FIND v(dout1_5) AT=1480.05n

.meas tran vdout1_6ck1470 FIND v(dout1_6) AT=1480.05n

.meas tran vdout1_7ck1470 FIND v(dout1_7) AT=1480.05n

.meas tran vdout1_8ck1470 FIND v(dout1_8) AT=1480.05n

.meas tran vdout1_9ck1470 FIND v(dout1_9) AT=1480.05n

.meas tran vdout1_10ck1470 FIND v(dout1_10) AT=1480.05n

.meas tran vdout1_11ck1470 FIND v(dout1_11) AT=1480.05n

.meas tran vdout1_12ck1470 FIND v(dout1_12) AT=1480.05n

.meas tran vdout1_13ck1470 FIND v(dout1_13) AT=1480.05n

.meas tran vdout1_14ck1470 FIND v(dout1_14) AT=1480.05n

.meas tran vdout1_15ck1470 FIND v(dout1_15) AT=1480.05n

.meas tran vdout1_16ck1470 FIND v(dout1_16) AT=1480.05n

.meas tran vdout1_17ck1470 FIND v(dout1_17) AT=1480.05n

.meas tran vdout1_18ck1470 FIND v(dout1_18) AT=1480.05n

.meas tran vdout1_0ck1510 FIND v(dout1_0) AT=1520.05n

.meas tran vdout1_1ck1510 FIND v(dout1_1) AT=1520.05n

.meas tran vdout1_2ck1510 FIND v(dout1_2) AT=1520.05n

.meas tran vdout1_3ck1510 FIND v(dout1_3) AT=1520.05n

.meas tran vdout1_4ck1510 FIND v(dout1_4) AT=1520.05n

.meas tran vdout1_5ck1510 FIND v(dout1_5) AT=1520.05n

.meas tran vdout1_6ck1510 FIND v(dout1_6) AT=1520.05n

.meas tran vdout1_7ck1510 FIND v(dout1_7) AT=1520.05n

.meas tran vdout1_8ck1510 FIND v(dout1_8) AT=1520.05n

.meas tran vdout1_9ck1510 FIND v(dout1_9) AT=1520.05n

.meas tran vdout1_10ck1510 FIND v(dout1_10) AT=1520.05n

.meas tran vdout1_11ck1510 FIND v(dout1_11) AT=1520.05n

.meas tran vdout1_12ck1510 FIND v(dout1_12) AT=1520.05n

.meas tran vdout1_13ck1510 FIND v(dout1_13) AT=1520.05n

.meas tran vdout1_14ck1510 FIND v(dout1_14) AT=1520.05n

.meas tran vdout1_15ck1510 FIND v(dout1_15) AT=1520.05n

.meas tran vdout1_16ck1510 FIND v(dout1_16) AT=1520.05n

.meas tran vdout1_17ck1510 FIND v(dout1_17) AT=1520.05n

.meas tran vdout1_18ck1510 FIND v(dout1_18) AT=1520.05n

.meas tran vdout1_0ck1550 FIND v(dout1_0) AT=1560.05n

.meas tran vdout1_1ck1550 FIND v(dout1_1) AT=1560.05n

.meas tran vdout1_2ck1550 FIND v(dout1_2) AT=1560.05n

.meas tran vdout1_3ck1550 FIND v(dout1_3) AT=1560.05n

.meas tran vdout1_4ck1550 FIND v(dout1_4) AT=1560.05n

.meas tran vdout1_5ck1550 FIND v(dout1_5) AT=1560.05n

.meas tran vdout1_6ck1550 FIND v(dout1_6) AT=1560.05n

.meas tran vdout1_7ck1550 FIND v(dout1_7) AT=1560.05n

.meas tran vdout1_8ck1550 FIND v(dout1_8) AT=1560.05n

.meas tran vdout1_9ck1550 FIND v(dout1_9) AT=1560.05n

.meas tran vdout1_10ck1550 FIND v(dout1_10) AT=1560.05n

.meas tran vdout1_11ck1550 FIND v(dout1_11) AT=1560.05n

.meas tran vdout1_12ck1550 FIND v(dout1_12) AT=1560.05n

.meas tran vdout1_13ck1550 FIND v(dout1_13) AT=1560.05n

.meas tran vdout1_14ck1550 FIND v(dout1_14) AT=1560.05n

.meas tran vdout1_15ck1550 FIND v(dout1_15) AT=1560.05n

.meas tran vdout1_16ck1550 FIND v(dout1_16) AT=1560.05n

.meas tran vdout1_17ck1550 FIND v(dout1_17) AT=1560.05n

.meas tran vdout1_18ck1550 FIND v(dout1_18) AT=1560.05n

.meas tran vdout1_0ck1570 FIND v(dout1_0) AT=1580.05n

.meas tran vdout1_1ck1570 FIND v(dout1_1) AT=1580.05n

.meas tran vdout1_2ck1570 FIND v(dout1_2) AT=1580.05n

.meas tran vdout1_3ck1570 FIND v(dout1_3) AT=1580.05n

.meas tran vdout1_4ck1570 FIND v(dout1_4) AT=1580.05n

.meas tran vdout1_5ck1570 FIND v(dout1_5) AT=1580.05n

.meas tran vdout1_6ck1570 FIND v(dout1_6) AT=1580.05n

.meas tran vdout1_7ck1570 FIND v(dout1_7) AT=1580.05n

.meas tran vdout1_8ck1570 FIND v(dout1_8) AT=1580.05n

.meas tran vdout1_9ck1570 FIND v(dout1_9) AT=1580.05n

.meas tran vdout1_10ck1570 FIND v(dout1_10) AT=1580.05n

.meas tran vdout1_11ck1570 FIND v(dout1_11) AT=1580.05n

.meas tran vdout1_12ck1570 FIND v(dout1_12) AT=1580.05n

.meas tran vdout1_13ck1570 FIND v(dout1_13) AT=1580.05n

.meas tran vdout1_14ck1570 FIND v(dout1_14) AT=1580.05n

.meas tran vdout1_15ck1570 FIND v(dout1_15) AT=1580.05n

.meas tran vdout1_16ck1570 FIND v(dout1_16) AT=1580.05n

.meas tran vdout1_17ck1570 FIND v(dout1_17) AT=1580.05n

.meas tran vdout1_18ck1570 FIND v(dout1_18) AT=1580.05n

.meas tran vdout1_0ck1580 FIND v(dout1_0) AT=1590.05n

.meas tran vdout1_1ck1580 FIND v(dout1_1) AT=1590.05n

.meas tran vdout1_2ck1580 FIND v(dout1_2) AT=1590.05n

.meas tran vdout1_3ck1580 FIND v(dout1_3) AT=1590.05n

.meas tran vdout1_4ck1580 FIND v(dout1_4) AT=1590.05n

.meas tran vdout1_5ck1580 FIND v(dout1_5) AT=1590.05n

.meas tran vdout1_6ck1580 FIND v(dout1_6) AT=1590.05n

.meas tran vdout1_7ck1580 FIND v(dout1_7) AT=1590.05n

.meas tran vdout1_8ck1580 FIND v(dout1_8) AT=1590.05n

.meas tran vdout1_9ck1580 FIND v(dout1_9) AT=1590.05n

.meas tran vdout1_10ck1580 FIND v(dout1_10) AT=1590.05n

.meas tran vdout1_11ck1580 FIND v(dout1_11) AT=1590.05n

.meas tran vdout1_12ck1580 FIND v(dout1_12) AT=1590.05n

.meas tran vdout1_13ck1580 FIND v(dout1_13) AT=1590.05n

.meas tran vdout1_14ck1580 FIND v(dout1_14) AT=1590.05n

.meas tran vdout1_15ck1580 FIND v(dout1_15) AT=1590.05n

.meas tran vdout1_16ck1580 FIND v(dout1_16) AT=1590.05n

.meas tran vdout1_17ck1580 FIND v(dout1_17) AT=1590.05n

.meas tran vdout1_18ck1580 FIND v(dout1_18) AT=1590.05n

.meas tran vdout1_0ck1610 FIND v(dout1_0) AT=1620.05n

.meas tran vdout1_1ck1610 FIND v(dout1_1) AT=1620.05n

.meas tran vdout1_2ck1610 FIND v(dout1_2) AT=1620.05n

.meas tran vdout1_3ck1610 FIND v(dout1_3) AT=1620.05n

.meas tran vdout1_4ck1610 FIND v(dout1_4) AT=1620.05n

.meas tran vdout1_5ck1610 FIND v(dout1_5) AT=1620.05n

.meas tran vdout1_6ck1610 FIND v(dout1_6) AT=1620.05n

.meas tran vdout1_7ck1610 FIND v(dout1_7) AT=1620.05n

.meas tran vdout1_8ck1610 FIND v(dout1_8) AT=1620.05n

.meas tran vdout1_9ck1610 FIND v(dout1_9) AT=1620.05n

.meas tran vdout1_10ck1610 FIND v(dout1_10) AT=1620.05n

.meas tran vdout1_11ck1610 FIND v(dout1_11) AT=1620.05n

.meas tran vdout1_12ck1610 FIND v(dout1_12) AT=1620.05n

.meas tran vdout1_13ck1610 FIND v(dout1_13) AT=1620.05n

.meas tran vdout1_14ck1610 FIND v(dout1_14) AT=1620.05n

.meas tran vdout1_15ck1610 FIND v(dout1_15) AT=1620.05n

.meas tran vdout1_16ck1610 FIND v(dout1_16) AT=1620.05n

.meas tran vdout1_17ck1610 FIND v(dout1_17) AT=1620.05n

.meas tran vdout1_18ck1610 FIND v(dout1_18) AT=1620.05n

.meas tran vdout1_0ck1660 FIND v(dout1_0) AT=1670.05n

.meas tran vdout1_1ck1660 FIND v(dout1_1) AT=1670.05n

.meas tran vdout1_2ck1660 FIND v(dout1_2) AT=1670.05n

.meas tran vdout1_3ck1660 FIND v(dout1_3) AT=1670.05n

.meas tran vdout1_4ck1660 FIND v(dout1_4) AT=1670.05n

.meas tran vdout1_5ck1660 FIND v(dout1_5) AT=1670.05n

.meas tran vdout1_6ck1660 FIND v(dout1_6) AT=1670.05n

.meas tran vdout1_7ck1660 FIND v(dout1_7) AT=1670.05n

.meas tran vdout1_8ck1660 FIND v(dout1_8) AT=1670.05n

.meas tran vdout1_9ck1660 FIND v(dout1_9) AT=1670.05n

.meas tran vdout1_10ck1660 FIND v(dout1_10) AT=1670.05n

.meas tran vdout1_11ck1660 FIND v(dout1_11) AT=1670.05n

.meas tran vdout1_12ck1660 FIND v(dout1_12) AT=1670.05n

.meas tran vdout1_13ck1660 FIND v(dout1_13) AT=1670.05n

.meas tran vdout1_14ck1660 FIND v(dout1_14) AT=1670.05n

.meas tran vdout1_15ck1660 FIND v(dout1_15) AT=1670.05n

.meas tran vdout1_16ck1660 FIND v(dout1_16) AT=1670.05n

.meas tran vdout1_17ck1660 FIND v(dout1_17) AT=1670.05n

.meas tran vdout1_18ck1660 FIND v(dout1_18) AT=1670.05n

.meas tran vdout1_0ck1710 FIND v(dout1_0) AT=1720.05n

.meas tran vdout1_1ck1710 FIND v(dout1_1) AT=1720.05n

.meas tran vdout1_2ck1710 FIND v(dout1_2) AT=1720.05n

.meas tran vdout1_3ck1710 FIND v(dout1_3) AT=1720.05n

.meas tran vdout1_4ck1710 FIND v(dout1_4) AT=1720.05n

.meas tran vdout1_5ck1710 FIND v(dout1_5) AT=1720.05n

.meas tran vdout1_6ck1710 FIND v(dout1_6) AT=1720.05n

.meas tran vdout1_7ck1710 FIND v(dout1_7) AT=1720.05n

.meas tran vdout1_8ck1710 FIND v(dout1_8) AT=1720.05n

.meas tran vdout1_9ck1710 FIND v(dout1_9) AT=1720.05n

.meas tran vdout1_10ck1710 FIND v(dout1_10) AT=1720.05n

.meas tran vdout1_11ck1710 FIND v(dout1_11) AT=1720.05n

.meas tran vdout1_12ck1710 FIND v(dout1_12) AT=1720.05n

.meas tran vdout1_13ck1710 FIND v(dout1_13) AT=1720.05n

.meas tran vdout1_14ck1710 FIND v(dout1_14) AT=1720.05n

.meas tran vdout1_15ck1710 FIND v(dout1_15) AT=1720.05n

.meas tran vdout1_16ck1710 FIND v(dout1_16) AT=1720.05n

.meas tran vdout1_17ck1710 FIND v(dout1_17) AT=1720.05n

.meas tran vdout1_18ck1710 FIND v(dout1_18) AT=1720.05n

.meas tran vdout1_0ck1720 FIND v(dout1_0) AT=1730.05n

.meas tran vdout1_1ck1720 FIND v(dout1_1) AT=1730.05n

.meas tran vdout1_2ck1720 FIND v(dout1_2) AT=1730.05n

.meas tran vdout1_3ck1720 FIND v(dout1_3) AT=1730.05n

.meas tran vdout1_4ck1720 FIND v(dout1_4) AT=1730.05n

.meas tran vdout1_5ck1720 FIND v(dout1_5) AT=1730.05n

.meas tran vdout1_6ck1720 FIND v(dout1_6) AT=1730.05n

.meas tran vdout1_7ck1720 FIND v(dout1_7) AT=1730.05n

.meas tran vdout1_8ck1720 FIND v(dout1_8) AT=1730.05n

.meas tran vdout1_9ck1720 FIND v(dout1_9) AT=1730.05n

.meas tran vdout1_10ck1720 FIND v(dout1_10) AT=1730.05n

.meas tran vdout1_11ck1720 FIND v(dout1_11) AT=1730.05n

.meas tran vdout1_12ck1720 FIND v(dout1_12) AT=1730.05n

.meas tran vdout1_13ck1720 FIND v(dout1_13) AT=1730.05n

.meas tran vdout1_14ck1720 FIND v(dout1_14) AT=1730.05n

.meas tran vdout1_15ck1720 FIND v(dout1_15) AT=1730.05n

.meas tran vdout1_16ck1720 FIND v(dout1_16) AT=1730.05n

.meas tran vdout1_17ck1720 FIND v(dout1_17) AT=1730.05n

.meas tran vdout1_18ck1720 FIND v(dout1_18) AT=1730.05n

.meas tran vdout1_0ck1730 FIND v(dout1_0) AT=1740.05n

.meas tran vdout1_1ck1730 FIND v(dout1_1) AT=1740.05n

.meas tran vdout1_2ck1730 FIND v(dout1_2) AT=1740.05n

.meas tran vdout1_3ck1730 FIND v(dout1_3) AT=1740.05n

.meas tran vdout1_4ck1730 FIND v(dout1_4) AT=1740.05n

.meas tran vdout1_5ck1730 FIND v(dout1_5) AT=1740.05n

.meas tran vdout1_6ck1730 FIND v(dout1_6) AT=1740.05n

.meas tran vdout1_7ck1730 FIND v(dout1_7) AT=1740.05n

.meas tran vdout1_8ck1730 FIND v(dout1_8) AT=1740.05n

.meas tran vdout1_9ck1730 FIND v(dout1_9) AT=1740.05n

.meas tran vdout1_10ck1730 FIND v(dout1_10) AT=1740.05n

.meas tran vdout1_11ck1730 FIND v(dout1_11) AT=1740.05n

.meas tran vdout1_12ck1730 FIND v(dout1_12) AT=1740.05n

.meas tran vdout1_13ck1730 FIND v(dout1_13) AT=1740.05n

.meas tran vdout1_14ck1730 FIND v(dout1_14) AT=1740.05n

.meas tran vdout1_15ck1730 FIND v(dout1_15) AT=1740.05n

.meas tran vdout1_16ck1730 FIND v(dout1_16) AT=1740.05n

.meas tran vdout1_17ck1730 FIND v(dout1_17) AT=1740.05n

.meas tran vdout1_18ck1730 FIND v(dout1_18) AT=1740.05n

.meas tran vdout1_0ck1740 FIND v(dout1_0) AT=1750.05n

.meas tran vdout1_1ck1740 FIND v(dout1_1) AT=1750.05n

.meas tran vdout1_2ck1740 FIND v(dout1_2) AT=1750.05n

.meas tran vdout1_3ck1740 FIND v(dout1_3) AT=1750.05n

.meas tran vdout1_4ck1740 FIND v(dout1_4) AT=1750.05n

.meas tran vdout1_5ck1740 FIND v(dout1_5) AT=1750.05n

.meas tran vdout1_6ck1740 FIND v(dout1_6) AT=1750.05n

.meas tran vdout1_7ck1740 FIND v(dout1_7) AT=1750.05n

.meas tran vdout1_8ck1740 FIND v(dout1_8) AT=1750.05n

.meas tran vdout1_9ck1740 FIND v(dout1_9) AT=1750.05n

.meas tran vdout1_10ck1740 FIND v(dout1_10) AT=1750.05n

.meas tran vdout1_11ck1740 FIND v(dout1_11) AT=1750.05n

.meas tran vdout1_12ck1740 FIND v(dout1_12) AT=1750.05n

.meas tran vdout1_13ck1740 FIND v(dout1_13) AT=1750.05n

.meas tran vdout1_14ck1740 FIND v(dout1_14) AT=1750.05n

.meas tran vdout1_15ck1740 FIND v(dout1_15) AT=1750.05n

.meas tran vdout1_16ck1740 FIND v(dout1_16) AT=1750.05n

.meas tran vdout1_17ck1740 FIND v(dout1_17) AT=1750.05n

.meas tran vdout1_18ck1740 FIND v(dout1_18) AT=1750.05n

.meas tran vdout1_0ck1750 FIND v(dout1_0) AT=1760.05n

.meas tran vdout1_1ck1750 FIND v(dout1_1) AT=1760.05n

.meas tran vdout1_2ck1750 FIND v(dout1_2) AT=1760.05n

.meas tran vdout1_3ck1750 FIND v(dout1_3) AT=1760.05n

.meas tran vdout1_4ck1750 FIND v(dout1_4) AT=1760.05n

.meas tran vdout1_5ck1750 FIND v(dout1_5) AT=1760.05n

.meas tran vdout1_6ck1750 FIND v(dout1_6) AT=1760.05n

.meas tran vdout1_7ck1750 FIND v(dout1_7) AT=1760.05n

.meas tran vdout1_8ck1750 FIND v(dout1_8) AT=1760.05n

.meas tran vdout1_9ck1750 FIND v(dout1_9) AT=1760.05n

.meas tran vdout1_10ck1750 FIND v(dout1_10) AT=1760.05n

.meas tran vdout1_11ck1750 FIND v(dout1_11) AT=1760.05n

.meas tran vdout1_12ck1750 FIND v(dout1_12) AT=1760.05n

.meas tran vdout1_13ck1750 FIND v(dout1_13) AT=1760.05n

.meas tran vdout1_14ck1750 FIND v(dout1_14) AT=1760.05n

.meas tran vdout1_15ck1750 FIND v(dout1_15) AT=1760.05n

.meas tran vdout1_16ck1750 FIND v(dout1_16) AT=1760.05n

.meas tran vdout1_17ck1750 FIND v(dout1_17) AT=1760.05n

.meas tran vdout1_18ck1750 FIND v(dout1_18) AT=1760.05n

.meas tran vdout1_0ck1760 FIND v(dout1_0) AT=1770.05n

.meas tran vdout1_1ck1760 FIND v(dout1_1) AT=1770.05n

.meas tran vdout1_2ck1760 FIND v(dout1_2) AT=1770.05n

.meas tran vdout1_3ck1760 FIND v(dout1_3) AT=1770.05n

.meas tran vdout1_4ck1760 FIND v(dout1_4) AT=1770.05n

.meas tran vdout1_5ck1760 FIND v(dout1_5) AT=1770.05n

.meas tran vdout1_6ck1760 FIND v(dout1_6) AT=1770.05n

.meas tran vdout1_7ck1760 FIND v(dout1_7) AT=1770.05n

.meas tran vdout1_8ck1760 FIND v(dout1_8) AT=1770.05n

.meas tran vdout1_9ck1760 FIND v(dout1_9) AT=1770.05n

.meas tran vdout1_10ck1760 FIND v(dout1_10) AT=1770.05n

.meas tran vdout1_11ck1760 FIND v(dout1_11) AT=1770.05n

.meas tran vdout1_12ck1760 FIND v(dout1_12) AT=1770.05n

.meas tran vdout1_13ck1760 FIND v(dout1_13) AT=1770.05n

.meas tran vdout1_14ck1760 FIND v(dout1_14) AT=1770.05n

.meas tran vdout1_15ck1760 FIND v(dout1_15) AT=1770.05n

.meas tran vdout1_16ck1760 FIND v(dout1_16) AT=1770.05n

.meas tran vdout1_17ck1760 FIND v(dout1_17) AT=1770.05n

.meas tran vdout1_18ck1760 FIND v(dout1_18) AT=1770.05n

.meas tran vdout1_0ck1780 FIND v(dout1_0) AT=1790.05n

.meas tran vdout1_1ck1780 FIND v(dout1_1) AT=1790.05n

.meas tran vdout1_2ck1780 FIND v(dout1_2) AT=1790.05n

.meas tran vdout1_3ck1780 FIND v(dout1_3) AT=1790.05n

.meas tran vdout1_4ck1780 FIND v(dout1_4) AT=1790.05n

.meas tran vdout1_5ck1780 FIND v(dout1_5) AT=1790.05n

.meas tran vdout1_6ck1780 FIND v(dout1_6) AT=1790.05n

.meas tran vdout1_7ck1780 FIND v(dout1_7) AT=1790.05n

.meas tran vdout1_8ck1780 FIND v(dout1_8) AT=1790.05n

.meas tran vdout1_9ck1780 FIND v(dout1_9) AT=1790.05n

.meas tran vdout1_10ck1780 FIND v(dout1_10) AT=1790.05n

.meas tran vdout1_11ck1780 FIND v(dout1_11) AT=1790.05n

.meas tran vdout1_12ck1780 FIND v(dout1_12) AT=1790.05n

.meas tran vdout1_13ck1780 FIND v(dout1_13) AT=1790.05n

.meas tran vdout1_14ck1780 FIND v(dout1_14) AT=1790.05n

.meas tran vdout1_15ck1780 FIND v(dout1_15) AT=1790.05n

.meas tran vdout1_16ck1780 FIND v(dout1_16) AT=1790.05n

.meas tran vdout1_17ck1780 FIND v(dout1_17) AT=1790.05n

.meas tran vdout1_18ck1780 FIND v(dout1_18) AT=1790.05n

.meas tran vdout1_0ck1840 FIND v(dout1_0) AT=1850.05n

.meas tran vdout1_1ck1840 FIND v(dout1_1) AT=1850.05n

.meas tran vdout1_2ck1840 FIND v(dout1_2) AT=1850.05n

.meas tran vdout1_3ck1840 FIND v(dout1_3) AT=1850.05n

.meas tran vdout1_4ck1840 FIND v(dout1_4) AT=1850.05n

.meas tran vdout1_5ck1840 FIND v(dout1_5) AT=1850.05n

.meas tran vdout1_6ck1840 FIND v(dout1_6) AT=1850.05n

.meas tran vdout1_7ck1840 FIND v(dout1_7) AT=1850.05n

.meas tran vdout1_8ck1840 FIND v(dout1_8) AT=1850.05n

.meas tran vdout1_9ck1840 FIND v(dout1_9) AT=1850.05n

.meas tran vdout1_10ck1840 FIND v(dout1_10) AT=1850.05n

.meas tran vdout1_11ck1840 FIND v(dout1_11) AT=1850.05n

.meas tran vdout1_12ck1840 FIND v(dout1_12) AT=1850.05n

.meas tran vdout1_13ck1840 FIND v(dout1_13) AT=1850.05n

.meas tran vdout1_14ck1840 FIND v(dout1_14) AT=1850.05n

.meas tran vdout1_15ck1840 FIND v(dout1_15) AT=1850.05n

.meas tran vdout1_16ck1840 FIND v(dout1_16) AT=1850.05n

.meas tran vdout1_17ck1840 FIND v(dout1_17) AT=1850.05n

.meas tran vdout1_18ck1840 FIND v(dout1_18) AT=1850.05n

.meas tran vdout1_0ck1850 FIND v(dout1_0) AT=1860.05n

.meas tran vdout1_1ck1850 FIND v(dout1_1) AT=1860.05n

.meas tran vdout1_2ck1850 FIND v(dout1_2) AT=1860.05n

.meas tran vdout1_3ck1850 FIND v(dout1_3) AT=1860.05n

.meas tran vdout1_4ck1850 FIND v(dout1_4) AT=1860.05n

.meas tran vdout1_5ck1850 FIND v(dout1_5) AT=1860.05n

.meas tran vdout1_6ck1850 FIND v(dout1_6) AT=1860.05n

.meas tran vdout1_7ck1850 FIND v(dout1_7) AT=1860.05n

.meas tran vdout1_8ck1850 FIND v(dout1_8) AT=1860.05n

.meas tran vdout1_9ck1850 FIND v(dout1_9) AT=1860.05n

.meas tran vdout1_10ck1850 FIND v(dout1_10) AT=1860.05n

.meas tran vdout1_11ck1850 FIND v(dout1_11) AT=1860.05n

.meas tran vdout1_12ck1850 FIND v(dout1_12) AT=1860.05n

.meas tran vdout1_13ck1850 FIND v(dout1_13) AT=1860.05n

.meas tran vdout1_14ck1850 FIND v(dout1_14) AT=1860.05n

.meas tran vdout1_15ck1850 FIND v(dout1_15) AT=1860.05n

.meas tran vdout1_16ck1850 FIND v(dout1_16) AT=1860.05n

.meas tran vdout1_17ck1850 FIND v(dout1_17) AT=1860.05n

.meas tran vdout1_18ck1850 FIND v(dout1_18) AT=1860.05n

.meas tran vdout1_0ck1900 FIND v(dout1_0) AT=1910.05n

.meas tran vdout1_1ck1900 FIND v(dout1_1) AT=1910.05n

.meas tran vdout1_2ck1900 FIND v(dout1_2) AT=1910.05n

.meas tran vdout1_3ck1900 FIND v(dout1_3) AT=1910.05n

.meas tran vdout1_4ck1900 FIND v(dout1_4) AT=1910.05n

.meas tran vdout1_5ck1900 FIND v(dout1_5) AT=1910.05n

.meas tran vdout1_6ck1900 FIND v(dout1_6) AT=1910.05n

.meas tran vdout1_7ck1900 FIND v(dout1_7) AT=1910.05n

.meas tran vdout1_8ck1900 FIND v(dout1_8) AT=1910.05n

.meas tran vdout1_9ck1900 FIND v(dout1_9) AT=1910.05n

.meas tran vdout1_10ck1900 FIND v(dout1_10) AT=1910.05n

.meas tran vdout1_11ck1900 FIND v(dout1_11) AT=1910.05n

.meas tran vdout1_12ck1900 FIND v(dout1_12) AT=1910.05n

.meas tran vdout1_13ck1900 FIND v(dout1_13) AT=1910.05n

.meas tran vdout1_14ck1900 FIND v(dout1_14) AT=1910.05n

.meas tran vdout1_15ck1900 FIND v(dout1_15) AT=1910.05n

.meas tran vdout1_16ck1900 FIND v(dout1_16) AT=1910.05n

.meas tran vdout1_17ck1900 FIND v(dout1_17) AT=1910.05n

.meas tran vdout1_18ck1900 FIND v(dout1_18) AT=1910.05n

.meas tran vdout1_0ck1920 FIND v(dout1_0) AT=1930.05n

.meas tran vdout1_1ck1920 FIND v(dout1_1) AT=1930.05n

.meas tran vdout1_2ck1920 FIND v(dout1_2) AT=1930.05n

.meas tran vdout1_3ck1920 FIND v(dout1_3) AT=1930.05n

.meas tran vdout1_4ck1920 FIND v(dout1_4) AT=1930.05n

.meas tran vdout1_5ck1920 FIND v(dout1_5) AT=1930.05n

.meas tran vdout1_6ck1920 FIND v(dout1_6) AT=1930.05n

.meas tran vdout1_7ck1920 FIND v(dout1_7) AT=1930.05n

.meas tran vdout1_8ck1920 FIND v(dout1_8) AT=1930.05n

.meas tran vdout1_9ck1920 FIND v(dout1_9) AT=1930.05n

.meas tran vdout1_10ck1920 FIND v(dout1_10) AT=1930.05n

.meas tran vdout1_11ck1920 FIND v(dout1_11) AT=1930.05n

.meas tran vdout1_12ck1920 FIND v(dout1_12) AT=1930.05n

.meas tran vdout1_13ck1920 FIND v(dout1_13) AT=1930.05n

.meas tran vdout1_14ck1920 FIND v(dout1_14) AT=1930.05n

.meas tran vdout1_15ck1920 FIND v(dout1_15) AT=1930.05n

.meas tran vdout1_16ck1920 FIND v(dout1_16) AT=1930.05n

.meas tran vdout1_17ck1920 FIND v(dout1_17) AT=1930.05n

.meas tran vdout1_18ck1920 FIND v(dout1_18) AT=1930.05n

.meas tran vdout1_0ck1960 FIND v(dout1_0) AT=1970.05n

.meas tran vdout1_1ck1960 FIND v(dout1_1) AT=1970.05n

.meas tran vdout1_2ck1960 FIND v(dout1_2) AT=1970.05n

.meas tran vdout1_3ck1960 FIND v(dout1_3) AT=1970.05n

.meas tran vdout1_4ck1960 FIND v(dout1_4) AT=1970.05n

.meas tran vdout1_5ck1960 FIND v(dout1_5) AT=1970.05n

.meas tran vdout1_6ck1960 FIND v(dout1_6) AT=1970.05n

.meas tran vdout1_7ck1960 FIND v(dout1_7) AT=1970.05n

.meas tran vdout1_8ck1960 FIND v(dout1_8) AT=1970.05n

.meas tran vdout1_9ck1960 FIND v(dout1_9) AT=1970.05n

.meas tran vdout1_10ck1960 FIND v(dout1_10) AT=1970.05n

.meas tran vdout1_11ck1960 FIND v(dout1_11) AT=1970.05n

.meas tran vdout1_12ck1960 FIND v(dout1_12) AT=1970.05n

.meas tran vdout1_13ck1960 FIND v(dout1_13) AT=1970.05n

.meas tran vdout1_14ck1960 FIND v(dout1_14) AT=1970.05n

.meas tran vdout1_15ck1960 FIND v(dout1_15) AT=1970.05n

.meas tran vdout1_16ck1960 FIND v(dout1_16) AT=1970.05n

.meas tran vdout1_17ck1960 FIND v(dout1_17) AT=1970.05n

.meas tran vdout1_18ck1960 FIND v(dout1_18) AT=1970.05n

.meas tran vdout1_0ck2000 FIND v(dout1_0) AT=2010.05n

.meas tran vdout1_1ck2000 FIND v(dout1_1) AT=2010.05n

.meas tran vdout1_2ck2000 FIND v(dout1_2) AT=2010.05n

.meas tran vdout1_3ck2000 FIND v(dout1_3) AT=2010.05n

.meas tran vdout1_4ck2000 FIND v(dout1_4) AT=2010.05n

.meas tran vdout1_5ck2000 FIND v(dout1_5) AT=2010.05n

.meas tran vdout1_6ck2000 FIND v(dout1_6) AT=2010.05n

.meas tran vdout1_7ck2000 FIND v(dout1_7) AT=2010.05n

.meas tran vdout1_8ck2000 FIND v(dout1_8) AT=2010.05n

.meas tran vdout1_9ck2000 FIND v(dout1_9) AT=2010.05n

.meas tran vdout1_10ck2000 FIND v(dout1_10) AT=2010.05n

.meas tran vdout1_11ck2000 FIND v(dout1_11) AT=2010.05n

.meas tran vdout1_12ck2000 FIND v(dout1_12) AT=2010.05n

.meas tran vdout1_13ck2000 FIND v(dout1_13) AT=2010.05n

.meas tran vdout1_14ck2000 FIND v(dout1_14) AT=2010.05n

.meas tran vdout1_15ck2000 FIND v(dout1_15) AT=2010.05n

.meas tran vdout1_16ck2000 FIND v(dout1_16) AT=2010.05n

.meas tran vdout1_17ck2000 FIND v(dout1_17) AT=2010.05n

.meas tran vdout1_18ck2000 FIND v(dout1_18) AT=2010.05n

.meas tran vdout1_0ck2020 FIND v(dout1_0) AT=2030.05n

.meas tran vdout1_1ck2020 FIND v(dout1_1) AT=2030.05n

.meas tran vdout1_2ck2020 FIND v(dout1_2) AT=2030.05n

.meas tran vdout1_3ck2020 FIND v(dout1_3) AT=2030.05n

.meas tran vdout1_4ck2020 FIND v(dout1_4) AT=2030.05n

.meas tran vdout1_5ck2020 FIND v(dout1_5) AT=2030.05n

.meas tran vdout1_6ck2020 FIND v(dout1_6) AT=2030.05n

.meas tran vdout1_7ck2020 FIND v(dout1_7) AT=2030.05n

.meas tran vdout1_8ck2020 FIND v(dout1_8) AT=2030.05n

.meas tran vdout1_9ck2020 FIND v(dout1_9) AT=2030.05n

.meas tran vdout1_10ck2020 FIND v(dout1_10) AT=2030.05n

.meas tran vdout1_11ck2020 FIND v(dout1_11) AT=2030.05n

.meas tran vdout1_12ck2020 FIND v(dout1_12) AT=2030.05n

.meas tran vdout1_13ck2020 FIND v(dout1_13) AT=2030.05n

.meas tran vdout1_14ck2020 FIND v(dout1_14) AT=2030.05n

.meas tran vdout1_15ck2020 FIND v(dout1_15) AT=2030.05n

.meas tran vdout1_16ck2020 FIND v(dout1_16) AT=2030.05n

.meas tran vdout1_17ck2020 FIND v(dout1_17) AT=2030.05n

.meas tran vdout1_18ck2020 FIND v(dout1_18) AT=2030.05n

.meas tran vdout1_0ck2030 FIND v(dout1_0) AT=2040.05n

.meas tran vdout1_1ck2030 FIND v(dout1_1) AT=2040.05n

.meas tran vdout1_2ck2030 FIND v(dout1_2) AT=2040.05n

.meas tran vdout1_3ck2030 FIND v(dout1_3) AT=2040.05n

.meas tran vdout1_4ck2030 FIND v(dout1_4) AT=2040.05n

.meas tran vdout1_5ck2030 FIND v(dout1_5) AT=2040.05n

.meas tran vdout1_6ck2030 FIND v(dout1_6) AT=2040.05n

.meas tran vdout1_7ck2030 FIND v(dout1_7) AT=2040.05n

.meas tran vdout1_8ck2030 FIND v(dout1_8) AT=2040.05n

.meas tran vdout1_9ck2030 FIND v(dout1_9) AT=2040.05n

.meas tran vdout1_10ck2030 FIND v(dout1_10) AT=2040.05n

.meas tran vdout1_11ck2030 FIND v(dout1_11) AT=2040.05n

.meas tran vdout1_12ck2030 FIND v(dout1_12) AT=2040.05n

.meas tran vdout1_13ck2030 FIND v(dout1_13) AT=2040.05n

.meas tran vdout1_14ck2030 FIND v(dout1_14) AT=2040.05n

.meas tran vdout1_15ck2030 FIND v(dout1_15) AT=2040.05n

.meas tran vdout1_16ck2030 FIND v(dout1_16) AT=2040.05n

.meas tran vdout1_17ck2030 FIND v(dout1_17) AT=2040.05n

.meas tran vdout1_18ck2030 FIND v(dout1_18) AT=2040.05n

.meas tran vdout1_0ck2040 FIND v(dout1_0) AT=2050.05n

.meas tran vdout1_1ck2040 FIND v(dout1_1) AT=2050.05n

.meas tran vdout1_2ck2040 FIND v(dout1_2) AT=2050.05n

.meas tran vdout1_3ck2040 FIND v(dout1_3) AT=2050.05n

.meas tran vdout1_4ck2040 FIND v(dout1_4) AT=2050.05n

.meas tran vdout1_5ck2040 FIND v(dout1_5) AT=2050.05n

.meas tran vdout1_6ck2040 FIND v(dout1_6) AT=2050.05n

.meas tran vdout1_7ck2040 FIND v(dout1_7) AT=2050.05n

.meas tran vdout1_8ck2040 FIND v(dout1_8) AT=2050.05n

.meas tran vdout1_9ck2040 FIND v(dout1_9) AT=2050.05n

.meas tran vdout1_10ck2040 FIND v(dout1_10) AT=2050.05n

.meas tran vdout1_11ck2040 FIND v(dout1_11) AT=2050.05n

.meas tran vdout1_12ck2040 FIND v(dout1_12) AT=2050.05n

.meas tran vdout1_13ck2040 FIND v(dout1_13) AT=2050.05n

.meas tran vdout1_14ck2040 FIND v(dout1_14) AT=2050.05n

.meas tran vdout1_15ck2040 FIND v(dout1_15) AT=2050.05n

.meas tran vdout1_16ck2040 FIND v(dout1_16) AT=2050.05n

.meas tran vdout1_17ck2040 FIND v(dout1_17) AT=2050.05n

.meas tran vdout1_18ck2040 FIND v(dout1_18) AT=2050.05n
