.meas tran vdout1_0ck40 FIND v(dout1_0) AT=50.05n

.meas tran vdout1_1ck40 FIND v(dout1_1) AT=50.05n

.meas tran vdout1_2ck40 FIND v(dout1_2) AT=50.05n

.meas tran vdout1_3ck40 FIND v(dout1_3) AT=50.05n

.meas tran vdout1_4ck40 FIND v(dout1_4) AT=50.05n

.meas tran vdout1_5ck40 FIND v(dout1_5) AT=50.05n

.meas tran vdout1_6ck40 FIND v(dout1_6) AT=50.05n

.meas tran vdout1_7ck40 FIND v(dout1_7) AT=50.05n

.meas tran vdout1_8ck40 FIND v(dout1_8) AT=50.05n

.meas tran vdout1_9ck40 FIND v(dout1_9) AT=50.05n

.meas tran vdout1_10ck40 FIND v(dout1_10) AT=50.05n

.meas tran vdout1_11ck40 FIND v(dout1_11) AT=50.05n

.meas tran vdout1_12ck40 FIND v(dout1_12) AT=50.05n

.meas tran vdout1_13ck40 FIND v(dout1_13) AT=50.05n

.meas tran vdout1_14ck40 FIND v(dout1_14) AT=50.05n

.meas tran vdout1_15ck40 FIND v(dout1_15) AT=50.05n

.meas tran vdout1_16ck40 FIND v(dout1_16) AT=50.05n

.meas tran vdout1_17ck40 FIND v(dout1_17) AT=50.05n

.meas tran vdout1_18ck40 FIND v(dout1_18) AT=50.05n

.meas tran vdout1_0ck60 FIND v(dout1_0) AT=70.05n

.meas tran vdout1_1ck60 FIND v(dout1_1) AT=70.05n

.meas tran vdout1_2ck60 FIND v(dout1_2) AT=70.05n

.meas tran vdout1_3ck60 FIND v(dout1_3) AT=70.05n

.meas tran vdout1_4ck60 FIND v(dout1_4) AT=70.05n

.meas tran vdout1_5ck60 FIND v(dout1_5) AT=70.05n

.meas tran vdout1_6ck60 FIND v(dout1_6) AT=70.05n

.meas tran vdout1_7ck60 FIND v(dout1_7) AT=70.05n

.meas tran vdout1_8ck60 FIND v(dout1_8) AT=70.05n

.meas tran vdout1_9ck60 FIND v(dout1_9) AT=70.05n

.meas tran vdout1_10ck60 FIND v(dout1_10) AT=70.05n

.meas tran vdout1_11ck60 FIND v(dout1_11) AT=70.05n

.meas tran vdout1_12ck60 FIND v(dout1_12) AT=70.05n

.meas tran vdout1_13ck60 FIND v(dout1_13) AT=70.05n

.meas tran vdout1_14ck60 FIND v(dout1_14) AT=70.05n

.meas tran vdout1_15ck60 FIND v(dout1_15) AT=70.05n

.meas tran vdout1_16ck60 FIND v(dout1_16) AT=70.05n

.meas tran vdout1_17ck60 FIND v(dout1_17) AT=70.05n

.meas tran vdout1_18ck60 FIND v(dout1_18) AT=70.05n

.meas tran vdout1_0ck130 FIND v(dout1_0) AT=140.05n

.meas tran vdout1_1ck130 FIND v(dout1_1) AT=140.05n

.meas tran vdout1_2ck130 FIND v(dout1_2) AT=140.05n

.meas tran vdout1_3ck130 FIND v(dout1_3) AT=140.05n

.meas tran vdout1_4ck130 FIND v(dout1_4) AT=140.05n

.meas tran vdout1_5ck130 FIND v(dout1_5) AT=140.05n

.meas tran vdout1_6ck130 FIND v(dout1_6) AT=140.05n

.meas tran vdout1_7ck130 FIND v(dout1_7) AT=140.05n

.meas tran vdout1_8ck130 FIND v(dout1_8) AT=140.05n

.meas tran vdout1_9ck130 FIND v(dout1_9) AT=140.05n

.meas tran vdout1_10ck130 FIND v(dout1_10) AT=140.05n

.meas tran vdout1_11ck130 FIND v(dout1_11) AT=140.05n

.meas tran vdout1_12ck130 FIND v(dout1_12) AT=140.05n

.meas tran vdout1_13ck130 FIND v(dout1_13) AT=140.05n

.meas tran vdout1_14ck130 FIND v(dout1_14) AT=140.05n

.meas tran vdout1_15ck130 FIND v(dout1_15) AT=140.05n

.meas tran vdout1_16ck130 FIND v(dout1_16) AT=140.05n

.meas tran vdout1_17ck130 FIND v(dout1_17) AT=140.05n

.meas tran vdout1_18ck130 FIND v(dout1_18) AT=140.05n

.meas tran vdout1_0ck190 FIND v(dout1_0) AT=200.05n

.meas tran vdout1_1ck190 FIND v(dout1_1) AT=200.05n

.meas tran vdout1_2ck190 FIND v(dout1_2) AT=200.05n

.meas tran vdout1_3ck190 FIND v(dout1_3) AT=200.05n

.meas tran vdout1_4ck190 FIND v(dout1_4) AT=200.05n

.meas tran vdout1_5ck190 FIND v(dout1_5) AT=200.05n

.meas tran vdout1_6ck190 FIND v(dout1_6) AT=200.05n

.meas tran vdout1_7ck190 FIND v(dout1_7) AT=200.05n

.meas tran vdout1_8ck190 FIND v(dout1_8) AT=200.05n

.meas tran vdout1_9ck190 FIND v(dout1_9) AT=200.05n

.meas tran vdout1_10ck190 FIND v(dout1_10) AT=200.05n

.meas tran vdout1_11ck190 FIND v(dout1_11) AT=200.05n

.meas tran vdout1_12ck190 FIND v(dout1_12) AT=200.05n

.meas tran vdout1_13ck190 FIND v(dout1_13) AT=200.05n

.meas tran vdout1_14ck190 FIND v(dout1_14) AT=200.05n

.meas tran vdout1_15ck190 FIND v(dout1_15) AT=200.05n

.meas tran vdout1_16ck190 FIND v(dout1_16) AT=200.05n

.meas tran vdout1_17ck190 FIND v(dout1_17) AT=200.05n

.meas tran vdout1_18ck190 FIND v(dout1_18) AT=200.05n

.meas tran vdout1_0ck240 FIND v(dout1_0) AT=250.05n

.meas tran vdout1_1ck240 FIND v(dout1_1) AT=250.05n

.meas tran vdout1_2ck240 FIND v(dout1_2) AT=250.05n

.meas tran vdout1_3ck240 FIND v(dout1_3) AT=250.05n

.meas tran vdout1_4ck240 FIND v(dout1_4) AT=250.05n

.meas tran vdout1_5ck240 FIND v(dout1_5) AT=250.05n

.meas tran vdout1_6ck240 FIND v(dout1_6) AT=250.05n

.meas tran vdout1_7ck240 FIND v(dout1_7) AT=250.05n

.meas tran vdout1_8ck240 FIND v(dout1_8) AT=250.05n

.meas tran vdout1_9ck240 FIND v(dout1_9) AT=250.05n

.meas tran vdout1_10ck240 FIND v(dout1_10) AT=250.05n

.meas tran vdout1_11ck240 FIND v(dout1_11) AT=250.05n

.meas tran vdout1_12ck240 FIND v(dout1_12) AT=250.05n

.meas tran vdout1_13ck240 FIND v(dout1_13) AT=250.05n

.meas tran vdout1_14ck240 FIND v(dout1_14) AT=250.05n

.meas tran vdout1_15ck240 FIND v(dout1_15) AT=250.05n

.meas tran vdout1_16ck240 FIND v(dout1_16) AT=250.05n

.meas tran vdout1_17ck240 FIND v(dout1_17) AT=250.05n

.meas tran vdout1_18ck240 FIND v(dout1_18) AT=250.05n

.meas tran vdout1_0ck260 FIND v(dout1_0) AT=270.05n

.meas tran vdout1_1ck260 FIND v(dout1_1) AT=270.05n

.meas tran vdout1_2ck260 FIND v(dout1_2) AT=270.05n

.meas tran vdout1_3ck260 FIND v(dout1_3) AT=270.05n

.meas tran vdout1_4ck260 FIND v(dout1_4) AT=270.05n

.meas tran vdout1_5ck260 FIND v(dout1_5) AT=270.05n

.meas tran vdout1_6ck260 FIND v(dout1_6) AT=270.05n

.meas tran vdout1_7ck260 FIND v(dout1_7) AT=270.05n

.meas tran vdout1_8ck260 FIND v(dout1_8) AT=270.05n

.meas tran vdout1_9ck260 FIND v(dout1_9) AT=270.05n

.meas tran vdout1_10ck260 FIND v(dout1_10) AT=270.05n

.meas tran vdout1_11ck260 FIND v(dout1_11) AT=270.05n

.meas tran vdout1_12ck260 FIND v(dout1_12) AT=270.05n

.meas tran vdout1_13ck260 FIND v(dout1_13) AT=270.05n

.meas tran vdout1_14ck260 FIND v(dout1_14) AT=270.05n

.meas tran vdout1_15ck260 FIND v(dout1_15) AT=270.05n

.meas tran vdout1_16ck260 FIND v(dout1_16) AT=270.05n

.meas tran vdout1_17ck260 FIND v(dout1_17) AT=270.05n

.meas tran vdout1_18ck260 FIND v(dout1_18) AT=270.05n

.meas tran vdout1_0ck280 FIND v(dout1_0) AT=290.05n

.meas tran vdout1_1ck280 FIND v(dout1_1) AT=290.05n

.meas tran vdout1_2ck280 FIND v(dout1_2) AT=290.05n

.meas tran vdout1_3ck280 FIND v(dout1_3) AT=290.05n

.meas tran vdout1_4ck280 FIND v(dout1_4) AT=290.05n

.meas tran vdout1_5ck280 FIND v(dout1_5) AT=290.05n

.meas tran vdout1_6ck280 FIND v(dout1_6) AT=290.05n

.meas tran vdout1_7ck280 FIND v(dout1_7) AT=290.05n

.meas tran vdout1_8ck280 FIND v(dout1_8) AT=290.05n

.meas tran vdout1_9ck280 FIND v(dout1_9) AT=290.05n

.meas tran vdout1_10ck280 FIND v(dout1_10) AT=290.05n

.meas tran vdout1_11ck280 FIND v(dout1_11) AT=290.05n

.meas tran vdout1_12ck280 FIND v(dout1_12) AT=290.05n

.meas tran vdout1_13ck280 FIND v(dout1_13) AT=290.05n

.meas tran vdout1_14ck280 FIND v(dout1_14) AT=290.05n

.meas tran vdout1_15ck280 FIND v(dout1_15) AT=290.05n

.meas tran vdout1_16ck280 FIND v(dout1_16) AT=290.05n

.meas tran vdout1_17ck280 FIND v(dout1_17) AT=290.05n

.meas tran vdout1_18ck280 FIND v(dout1_18) AT=290.05n

.meas tran vdout1_0ck330 FIND v(dout1_0) AT=340.05n

.meas tran vdout1_1ck330 FIND v(dout1_1) AT=340.05n

.meas tran vdout1_2ck330 FIND v(dout1_2) AT=340.05n

.meas tran vdout1_3ck330 FIND v(dout1_3) AT=340.05n

.meas tran vdout1_4ck330 FIND v(dout1_4) AT=340.05n

.meas tran vdout1_5ck330 FIND v(dout1_5) AT=340.05n

.meas tran vdout1_6ck330 FIND v(dout1_6) AT=340.05n

.meas tran vdout1_7ck330 FIND v(dout1_7) AT=340.05n

.meas tran vdout1_8ck330 FIND v(dout1_8) AT=340.05n

.meas tran vdout1_9ck330 FIND v(dout1_9) AT=340.05n

.meas tran vdout1_10ck330 FIND v(dout1_10) AT=340.05n

.meas tran vdout1_11ck330 FIND v(dout1_11) AT=340.05n

.meas tran vdout1_12ck330 FIND v(dout1_12) AT=340.05n

.meas tran vdout1_13ck330 FIND v(dout1_13) AT=340.05n

.meas tran vdout1_14ck330 FIND v(dout1_14) AT=340.05n

.meas tran vdout1_15ck330 FIND v(dout1_15) AT=340.05n

.meas tran vdout1_16ck330 FIND v(dout1_16) AT=340.05n

.meas tran vdout1_17ck330 FIND v(dout1_17) AT=340.05n

.meas tran vdout1_18ck330 FIND v(dout1_18) AT=340.05n

.meas tran vdout1_0ck360 FIND v(dout1_0) AT=370.05n

.meas tran vdout1_1ck360 FIND v(dout1_1) AT=370.05n

.meas tran vdout1_2ck360 FIND v(dout1_2) AT=370.05n

.meas tran vdout1_3ck360 FIND v(dout1_3) AT=370.05n

.meas tran vdout1_4ck360 FIND v(dout1_4) AT=370.05n

.meas tran vdout1_5ck360 FIND v(dout1_5) AT=370.05n

.meas tran vdout1_6ck360 FIND v(dout1_6) AT=370.05n

.meas tran vdout1_7ck360 FIND v(dout1_7) AT=370.05n

.meas tran vdout1_8ck360 FIND v(dout1_8) AT=370.05n

.meas tran vdout1_9ck360 FIND v(dout1_9) AT=370.05n

.meas tran vdout1_10ck360 FIND v(dout1_10) AT=370.05n

.meas tran vdout1_11ck360 FIND v(dout1_11) AT=370.05n

.meas tran vdout1_12ck360 FIND v(dout1_12) AT=370.05n

.meas tran vdout1_13ck360 FIND v(dout1_13) AT=370.05n

.meas tran vdout1_14ck360 FIND v(dout1_14) AT=370.05n

.meas tran vdout1_15ck360 FIND v(dout1_15) AT=370.05n

.meas tran vdout1_16ck360 FIND v(dout1_16) AT=370.05n

.meas tran vdout1_17ck360 FIND v(dout1_17) AT=370.05n

.meas tran vdout1_18ck360 FIND v(dout1_18) AT=370.05n

.meas tran vdout1_0ck400 FIND v(dout1_0) AT=410.05n

.meas tran vdout1_1ck400 FIND v(dout1_1) AT=410.05n

.meas tran vdout1_2ck400 FIND v(dout1_2) AT=410.05n

.meas tran vdout1_3ck400 FIND v(dout1_3) AT=410.05n

.meas tran vdout1_4ck400 FIND v(dout1_4) AT=410.05n

.meas tran vdout1_5ck400 FIND v(dout1_5) AT=410.05n

.meas tran vdout1_6ck400 FIND v(dout1_6) AT=410.05n

.meas tran vdout1_7ck400 FIND v(dout1_7) AT=410.05n

.meas tran vdout1_8ck400 FIND v(dout1_8) AT=410.05n

.meas tran vdout1_9ck400 FIND v(dout1_9) AT=410.05n

.meas tran vdout1_10ck400 FIND v(dout1_10) AT=410.05n

.meas tran vdout1_11ck400 FIND v(dout1_11) AT=410.05n

.meas tran vdout1_12ck400 FIND v(dout1_12) AT=410.05n

.meas tran vdout1_13ck400 FIND v(dout1_13) AT=410.05n

.meas tran vdout1_14ck400 FIND v(dout1_14) AT=410.05n

.meas tran vdout1_15ck400 FIND v(dout1_15) AT=410.05n

.meas tran vdout1_16ck400 FIND v(dout1_16) AT=410.05n

.meas tran vdout1_17ck400 FIND v(dout1_17) AT=410.05n

.meas tran vdout1_18ck400 FIND v(dout1_18) AT=410.05n

.meas tran vdout1_0ck410 FIND v(dout1_0) AT=420.05n

.meas tran vdout1_1ck410 FIND v(dout1_1) AT=420.05n

.meas tran vdout1_2ck410 FIND v(dout1_2) AT=420.05n

.meas tran vdout1_3ck410 FIND v(dout1_3) AT=420.05n

.meas tran vdout1_4ck410 FIND v(dout1_4) AT=420.05n

.meas tran vdout1_5ck410 FIND v(dout1_5) AT=420.05n

.meas tran vdout1_6ck410 FIND v(dout1_6) AT=420.05n

.meas tran vdout1_7ck410 FIND v(dout1_7) AT=420.05n

.meas tran vdout1_8ck410 FIND v(dout1_8) AT=420.05n

.meas tran vdout1_9ck410 FIND v(dout1_9) AT=420.05n

.meas tran vdout1_10ck410 FIND v(dout1_10) AT=420.05n

.meas tran vdout1_11ck410 FIND v(dout1_11) AT=420.05n

.meas tran vdout1_12ck410 FIND v(dout1_12) AT=420.05n

.meas tran vdout1_13ck410 FIND v(dout1_13) AT=420.05n

.meas tran vdout1_14ck410 FIND v(dout1_14) AT=420.05n

.meas tran vdout1_15ck410 FIND v(dout1_15) AT=420.05n

.meas tran vdout1_16ck410 FIND v(dout1_16) AT=420.05n

.meas tran vdout1_17ck410 FIND v(dout1_17) AT=420.05n

.meas tran vdout1_18ck410 FIND v(dout1_18) AT=420.05n

.meas tran vdout1_0ck420 FIND v(dout1_0) AT=430.05n

.meas tran vdout1_1ck420 FIND v(dout1_1) AT=430.05n

.meas tran vdout1_2ck420 FIND v(dout1_2) AT=430.05n

.meas tran vdout1_3ck420 FIND v(dout1_3) AT=430.05n

.meas tran vdout1_4ck420 FIND v(dout1_4) AT=430.05n

.meas tran vdout1_5ck420 FIND v(dout1_5) AT=430.05n

.meas tran vdout1_6ck420 FIND v(dout1_6) AT=430.05n

.meas tran vdout1_7ck420 FIND v(dout1_7) AT=430.05n

.meas tran vdout1_8ck420 FIND v(dout1_8) AT=430.05n

.meas tran vdout1_9ck420 FIND v(dout1_9) AT=430.05n

.meas tran vdout1_10ck420 FIND v(dout1_10) AT=430.05n

.meas tran vdout1_11ck420 FIND v(dout1_11) AT=430.05n

.meas tran vdout1_12ck420 FIND v(dout1_12) AT=430.05n

.meas tran vdout1_13ck420 FIND v(dout1_13) AT=430.05n

.meas tran vdout1_14ck420 FIND v(dout1_14) AT=430.05n

.meas tran vdout1_15ck420 FIND v(dout1_15) AT=430.05n

.meas tran vdout1_16ck420 FIND v(dout1_16) AT=430.05n

.meas tran vdout1_17ck420 FIND v(dout1_17) AT=430.05n

.meas tran vdout1_18ck420 FIND v(dout1_18) AT=430.05n

.meas tran vdout1_0ck490 FIND v(dout1_0) AT=500.05n

.meas tran vdout1_1ck490 FIND v(dout1_1) AT=500.05n

.meas tran vdout1_2ck490 FIND v(dout1_2) AT=500.05n

.meas tran vdout1_3ck490 FIND v(dout1_3) AT=500.05n

.meas tran vdout1_4ck490 FIND v(dout1_4) AT=500.05n

.meas tran vdout1_5ck490 FIND v(dout1_5) AT=500.05n

.meas tran vdout1_6ck490 FIND v(dout1_6) AT=500.05n

.meas tran vdout1_7ck490 FIND v(dout1_7) AT=500.05n

.meas tran vdout1_8ck490 FIND v(dout1_8) AT=500.05n

.meas tran vdout1_9ck490 FIND v(dout1_9) AT=500.05n

.meas tran vdout1_10ck490 FIND v(dout1_10) AT=500.05n

.meas tran vdout1_11ck490 FIND v(dout1_11) AT=500.05n

.meas tran vdout1_12ck490 FIND v(dout1_12) AT=500.05n

.meas tran vdout1_13ck490 FIND v(dout1_13) AT=500.05n

.meas tran vdout1_14ck490 FIND v(dout1_14) AT=500.05n

.meas tran vdout1_15ck490 FIND v(dout1_15) AT=500.05n

.meas tran vdout1_16ck490 FIND v(dout1_16) AT=500.05n

.meas tran vdout1_17ck490 FIND v(dout1_17) AT=500.05n

.meas tran vdout1_18ck490 FIND v(dout1_18) AT=500.05n

.meas tran vdout1_0ck530 FIND v(dout1_0) AT=540.05n

.meas tran vdout1_1ck530 FIND v(dout1_1) AT=540.05n

.meas tran vdout1_2ck530 FIND v(dout1_2) AT=540.05n

.meas tran vdout1_3ck530 FIND v(dout1_3) AT=540.05n

.meas tran vdout1_4ck530 FIND v(dout1_4) AT=540.05n

.meas tran vdout1_5ck530 FIND v(dout1_5) AT=540.05n

.meas tran vdout1_6ck530 FIND v(dout1_6) AT=540.05n

.meas tran vdout1_7ck530 FIND v(dout1_7) AT=540.05n

.meas tran vdout1_8ck530 FIND v(dout1_8) AT=540.05n

.meas tran vdout1_9ck530 FIND v(dout1_9) AT=540.05n

.meas tran vdout1_10ck530 FIND v(dout1_10) AT=540.05n

.meas tran vdout1_11ck530 FIND v(dout1_11) AT=540.05n

.meas tran vdout1_12ck530 FIND v(dout1_12) AT=540.05n

.meas tran vdout1_13ck530 FIND v(dout1_13) AT=540.05n

.meas tran vdout1_14ck530 FIND v(dout1_14) AT=540.05n

.meas tran vdout1_15ck530 FIND v(dout1_15) AT=540.05n

.meas tran vdout1_16ck530 FIND v(dout1_16) AT=540.05n

.meas tran vdout1_17ck530 FIND v(dout1_17) AT=540.05n

.meas tran vdout1_18ck530 FIND v(dout1_18) AT=540.05n

.meas tran vdout1_0ck600 FIND v(dout1_0) AT=610.05n

.meas tran vdout1_1ck600 FIND v(dout1_1) AT=610.05n

.meas tran vdout1_2ck600 FIND v(dout1_2) AT=610.05n

.meas tran vdout1_3ck600 FIND v(dout1_3) AT=610.05n

.meas tran vdout1_4ck600 FIND v(dout1_4) AT=610.05n

.meas tran vdout1_5ck600 FIND v(dout1_5) AT=610.05n

.meas tran vdout1_6ck600 FIND v(dout1_6) AT=610.05n

.meas tran vdout1_7ck600 FIND v(dout1_7) AT=610.05n

.meas tran vdout1_8ck600 FIND v(dout1_8) AT=610.05n

.meas tran vdout1_9ck600 FIND v(dout1_9) AT=610.05n

.meas tran vdout1_10ck600 FIND v(dout1_10) AT=610.05n

.meas tran vdout1_11ck600 FIND v(dout1_11) AT=610.05n

.meas tran vdout1_12ck600 FIND v(dout1_12) AT=610.05n

.meas tran vdout1_13ck600 FIND v(dout1_13) AT=610.05n

.meas tran vdout1_14ck600 FIND v(dout1_14) AT=610.05n

.meas tran vdout1_15ck600 FIND v(dout1_15) AT=610.05n

.meas tran vdout1_16ck600 FIND v(dout1_16) AT=610.05n

.meas tran vdout1_17ck600 FIND v(dout1_17) AT=610.05n

.meas tran vdout1_18ck600 FIND v(dout1_18) AT=610.05n

.meas tran vdout1_0ck620 FIND v(dout1_0) AT=630.05n

.meas tran vdout1_1ck620 FIND v(dout1_1) AT=630.05n

.meas tran vdout1_2ck620 FIND v(dout1_2) AT=630.05n

.meas tran vdout1_3ck620 FIND v(dout1_3) AT=630.05n

.meas tran vdout1_4ck620 FIND v(dout1_4) AT=630.05n

.meas tran vdout1_5ck620 FIND v(dout1_5) AT=630.05n

.meas tran vdout1_6ck620 FIND v(dout1_6) AT=630.05n

.meas tran vdout1_7ck620 FIND v(dout1_7) AT=630.05n

.meas tran vdout1_8ck620 FIND v(dout1_8) AT=630.05n

.meas tran vdout1_9ck620 FIND v(dout1_9) AT=630.05n

.meas tran vdout1_10ck620 FIND v(dout1_10) AT=630.05n

.meas tran vdout1_11ck620 FIND v(dout1_11) AT=630.05n

.meas tran vdout1_12ck620 FIND v(dout1_12) AT=630.05n

.meas tran vdout1_13ck620 FIND v(dout1_13) AT=630.05n

.meas tran vdout1_14ck620 FIND v(dout1_14) AT=630.05n

.meas tran vdout1_15ck620 FIND v(dout1_15) AT=630.05n

.meas tran vdout1_16ck620 FIND v(dout1_16) AT=630.05n

.meas tran vdout1_17ck620 FIND v(dout1_17) AT=630.05n

.meas tran vdout1_18ck620 FIND v(dout1_18) AT=630.05n

.meas tran vdout1_0ck640 FIND v(dout1_0) AT=650.05n

.meas tran vdout1_1ck640 FIND v(dout1_1) AT=650.05n

.meas tran vdout1_2ck640 FIND v(dout1_2) AT=650.05n

.meas tran vdout1_3ck640 FIND v(dout1_3) AT=650.05n

.meas tran vdout1_4ck640 FIND v(dout1_4) AT=650.05n

.meas tran vdout1_5ck640 FIND v(dout1_5) AT=650.05n

.meas tran vdout1_6ck640 FIND v(dout1_6) AT=650.05n

.meas tran vdout1_7ck640 FIND v(dout1_7) AT=650.05n

.meas tran vdout1_8ck640 FIND v(dout1_8) AT=650.05n

.meas tran vdout1_9ck640 FIND v(dout1_9) AT=650.05n

.meas tran vdout1_10ck640 FIND v(dout1_10) AT=650.05n

.meas tran vdout1_11ck640 FIND v(dout1_11) AT=650.05n

.meas tran vdout1_12ck640 FIND v(dout1_12) AT=650.05n

.meas tran vdout1_13ck640 FIND v(dout1_13) AT=650.05n

.meas tran vdout1_14ck640 FIND v(dout1_14) AT=650.05n

.meas tran vdout1_15ck640 FIND v(dout1_15) AT=650.05n

.meas tran vdout1_16ck640 FIND v(dout1_16) AT=650.05n

.meas tran vdout1_17ck640 FIND v(dout1_17) AT=650.05n

.meas tran vdout1_18ck640 FIND v(dout1_18) AT=650.05n

.meas tran vdout1_0ck650 FIND v(dout1_0) AT=660.05n

.meas tran vdout1_1ck650 FIND v(dout1_1) AT=660.05n

.meas tran vdout1_2ck650 FIND v(dout1_2) AT=660.05n

.meas tran vdout1_3ck650 FIND v(dout1_3) AT=660.05n

.meas tran vdout1_4ck650 FIND v(dout1_4) AT=660.05n

.meas tran vdout1_5ck650 FIND v(dout1_5) AT=660.05n

.meas tran vdout1_6ck650 FIND v(dout1_6) AT=660.05n

.meas tran vdout1_7ck650 FIND v(dout1_7) AT=660.05n

.meas tran vdout1_8ck650 FIND v(dout1_8) AT=660.05n

.meas tran vdout1_9ck650 FIND v(dout1_9) AT=660.05n

.meas tran vdout1_10ck650 FIND v(dout1_10) AT=660.05n

.meas tran vdout1_11ck650 FIND v(dout1_11) AT=660.05n

.meas tran vdout1_12ck650 FIND v(dout1_12) AT=660.05n

.meas tran vdout1_13ck650 FIND v(dout1_13) AT=660.05n

.meas tran vdout1_14ck650 FIND v(dout1_14) AT=660.05n

.meas tran vdout1_15ck650 FIND v(dout1_15) AT=660.05n

.meas tran vdout1_16ck650 FIND v(dout1_16) AT=660.05n

.meas tran vdout1_17ck650 FIND v(dout1_17) AT=660.05n

.meas tran vdout1_18ck650 FIND v(dout1_18) AT=660.05n

.meas tran vdout1_0ck720 FIND v(dout1_0) AT=730.05n

.meas tran vdout1_1ck720 FIND v(dout1_1) AT=730.05n

.meas tran vdout1_2ck720 FIND v(dout1_2) AT=730.05n

.meas tran vdout1_3ck720 FIND v(dout1_3) AT=730.05n

.meas tran vdout1_4ck720 FIND v(dout1_4) AT=730.05n

.meas tran vdout1_5ck720 FIND v(dout1_5) AT=730.05n

.meas tran vdout1_6ck720 FIND v(dout1_6) AT=730.05n

.meas tran vdout1_7ck720 FIND v(dout1_7) AT=730.05n

.meas tran vdout1_8ck720 FIND v(dout1_8) AT=730.05n

.meas tran vdout1_9ck720 FIND v(dout1_9) AT=730.05n

.meas tran vdout1_10ck720 FIND v(dout1_10) AT=730.05n

.meas tran vdout1_11ck720 FIND v(dout1_11) AT=730.05n

.meas tran vdout1_12ck720 FIND v(dout1_12) AT=730.05n

.meas tran vdout1_13ck720 FIND v(dout1_13) AT=730.05n

.meas tran vdout1_14ck720 FIND v(dout1_14) AT=730.05n

.meas tran vdout1_15ck720 FIND v(dout1_15) AT=730.05n

.meas tran vdout1_16ck720 FIND v(dout1_16) AT=730.05n

.meas tran vdout1_17ck720 FIND v(dout1_17) AT=730.05n

.meas tran vdout1_18ck720 FIND v(dout1_18) AT=730.05n

.meas tran vdout1_0ck780 FIND v(dout1_0) AT=790.05n

.meas tran vdout1_1ck780 FIND v(dout1_1) AT=790.05n

.meas tran vdout1_2ck780 FIND v(dout1_2) AT=790.05n

.meas tran vdout1_3ck780 FIND v(dout1_3) AT=790.05n

.meas tran vdout1_4ck780 FIND v(dout1_4) AT=790.05n

.meas tran vdout1_5ck780 FIND v(dout1_5) AT=790.05n

.meas tran vdout1_6ck780 FIND v(dout1_6) AT=790.05n

.meas tran vdout1_7ck780 FIND v(dout1_7) AT=790.05n

.meas tran vdout1_8ck780 FIND v(dout1_8) AT=790.05n

.meas tran vdout1_9ck780 FIND v(dout1_9) AT=790.05n

.meas tran vdout1_10ck780 FIND v(dout1_10) AT=790.05n

.meas tran vdout1_11ck780 FIND v(dout1_11) AT=790.05n

.meas tran vdout1_12ck780 FIND v(dout1_12) AT=790.05n

.meas tran vdout1_13ck780 FIND v(dout1_13) AT=790.05n

.meas tran vdout1_14ck780 FIND v(dout1_14) AT=790.05n

.meas tran vdout1_15ck780 FIND v(dout1_15) AT=790.05n

.meas tran vdout1_16ck780 FIND v(dout1_16) AT=790.05n

.meas tran vdout1_17ck780 FIND v(dout1_17) AT=790.05n

.meas tran vdout1_18ck780 FIND v(dout1_18) AT=790.05n

.meas tran vdout1_0ck840 FIND v(dout1_0) AT=850.05n

.meas tran vdout1_1ck840 FIND v(dout1_1) AT=850.05n

.meas tran vdout1_2ck840 FIND v(dout1_2) AT=850.05n

.meas tran vdout1_3ck840 FIND v(dout1_3) AT=850.05n

.meas tran vdout1_4ck840 FIND v(dout1_4) AT=850.05n

.meas tran vdout1_5ck840 FIND v(dout1_5) AT=850.05n

.meas tran vdout1_6ck840 FIND v(dout1_6) AT=850.05n

.meas tran vdout1_7ck840 FIND v(dout1_7) AT=850.05n

.meas tran vdout1_8ck840 FIND v(dout1_8) AT=850.05n

.meas tran vdout1_9ck840 FIND v(dout1_9) AT=850.05n

.meas tran vdout1_10ck840 FIND v(dout1_10) AT=850.05n

.meas tran vdout1_11ck840 FIND v(dout1_11) AT=850.05n

.meas tran vdout1_12ck840 FIND v(dout1_12) AT=850.05n

.meas tran vdout1_13ck840 FIND v(dout1_13) AT=850.05n

.meas tran vdout1_14ck840 FIND v(dout1_14) AT=850.05n

.meas tran vdout1_15ck840 FIND v(dout1_15) AT=850.05n

.meas tran vdout1_16ck840 FIND v(dout1_16) AT=850.05n

.meas tran vdout1_17ck840 FIND v(dout1_17) AT=850.05n

.meas tran vdout1_18ck840 FIND v(dout1_18) AT=850.05n

.meas tran vdout1_0ck850 FIND v(dout1_0) AT=860.05n

.meas tran vdout1_1ck850 FIND v(dout1_1) AT=860.05n

.meas tran vdout1_2ck850 FIND v(dout1_2) AT=860.05n

.meas tran vdout1_3ck850 FIND v(dout1_3) AT=860.05n

.meas tran vdout1_4ck850 FIND v(dout1_4) AT=860.05n

.meas tran vdout1_5ck850 FIND v(dout1_5) AT=860.05n

.meas tran vdout1_6ck850 FIND v(dout1_6) AT=860.05n

.meas tran vdout1_7ck850 FIND v(dout1_7) AT=860.05n

.meas tran vdout1_8ck850 FIND v(dout1_8) AT=860.05n

.meas tran vdout1_9ck850 FIND v(dout1_9) AT=860.05n

.meas tran vdout1_10ck850 FIND v(dout1_10) AT=860.05n

.meas tran vdout1_11ck850 FIND v(dout1_11) AT=860.05n

.meas tran vdout1_12ck850 FIND v(dout1_12) AT=860.05n

.meas tran vdout1_13ck850 FIND v(dout1_13) AT=860.05n

.meas tran vdout1_14ck850 FIND v(dout1_14) AT=860.05n

.meas tran vdout1_15ck850 FIND v(dout1_15) AT=860.05n

.meas tran vdout1_16ck850 FIND v(dout1_16) AT=860.05n

.meas tran vdout1_17ck850 FIND v(dout1_17) AT=860.05n

.meas tran vdout1_18ck850 FIND v(dout1_18) AT=860.05n

.meas tran vdout1_0ck860 FIND v(dout1_0) AT=870.05n

.meas tran vdout1_1ck860 FIND v(dout1_1) AT=870.05n

.meas tran vdout1_2ck860 FIND v(dout1_2) AT=870.05n

.meas tran vdout1_3ck860 FIND v(dout1_3) AT=870.05n

.meas tran vdout1_4ck860 FIND v(dout1_4) AT=870.05n

.meas tran vdout1_5ck860 FIND v(dout1_5) AT=870.05n

.meas tran vdout1_6ck860 FIND v(dout1_6) AT=870.05n

.meas tran vdout1_7ck860 FIND v(dout1_7) AT=870.05n

.meas tran vdout1_8ck860 FIND v(dout1_8) AT=870.05n

.meas tran vdout1_9ck860 FIND v(dout1_9) AT=870.05n

.meas tran vdout1_10ck860 FIND v(dout1_10) AT=870.05n

.meas tran vdout1_11ck860 FIND v(dout1_11) AT=870.05n

.meas tran vdout1_12ck860 FIND v(dout1_12) AT=870.05n

.meas tran vdout1_13ck860 FIND v(dout1_13) AT=870.05n

.meas tran vdout1_14ck860 FIND v(dout1_14) AT=870.05n

.meas tran vdout1_15ck860 FIND v(dout1_15) AT=870.05n

.meas tran vdout1_16ck860 FIND v(dout1_16) AT=870.05n

.meas tran vdout1_17ck860 FIND v(dout1_17) AT=870.05n

.meas tran vdout1_18ck860 FIND v(dout1_18) AT=870.05n

.meas tran vdout1_0ck880 FIND v(dout1_0) AT=890.05n

.meas tran vdout1_1ck880 FIND v(dout1_1) AT=890.05n

.meas tran vdout1_2ck880 FIND v(dout1_2) AT=890.05n

.meas tran vdout1_3ck880 FIND v(dout1_3) AT=890.05n

.meas tran vdout1_4ck880 FIND v(dout1_4) AT=890.05n

.meas tran vdout1_5ck880 FIND v(dout1_5) AT=890.05n

.meas tran vdout1_6ck880 FIND v(dout1_6) AT=890.05n

.meas tran vdout1_7ck880 FIND v(dout1_7) AT=890.05n

.meas tran vdout1_8ck880 FIND v(dout1_8) AT=890.05n

.meas tran vdout1_9ck880 FIND v(dout1_9) AT=890.05n

.meas tran vdout1_10ck880 FIND v(dout1_10) AT=890.05n

.meas tran vdout1_11ck880 FIND v(dout1_11) AT=890.05n

.meas tran vdout1_12ck880 FIND v(dout1_12) AT=890.05n

.meas tran vdout1_13ck880 FIND v(dout1_13) AT=890.05n

.meas tran vdout1_14ck880 FIND v(dout1_14) AT=890.05n

.meas tran vdout1_15ck880 FIND v(dout1_15) AT=890.05n

.meas tran vdout1_16ck880 FIND v(dout1_16) AT=890.05n

.meas tran vdout1_17ck880 FIND v(dout1_17) AT=890.05n

.meas tran vdout1_18ck880 FIND v(dout1_18) AT=890.05n

.meas tran vdout1_0ck940 FIND v(dout1_0) AT=950.05n

.meas tran vdout1_1ck940 FIND v(dout1_1) AT=950.05n

.meas tran vdout1_2ck940 FIND v(dout1_2) AT=950.05n

.meas tran vdout1_3ck940 FIND v(dout1_3) AT=950.05n

.meas tran vdout1_4ck940 FIND v(dout1_4) AT=950.05n

.meas tran vdout1_5ck940 FIND v(dout1_5) AT=950.05n

.meas tran vdout1_6ck940 FIND v(dout1_6) AT=950.05n

.meas tran vdout1_7ck940 FIND v(dout1_7) AT=950.05n

.meas tran vdout1_8ck940 FIND v(dout1_8) AT=950.05n

.meas tran vdout1_9ck940 FIND v(dout1_9) AT=950.05n

.meas tran vdout1_10ck940 FIND v(dout1_10) AT=950.05n

.meas tran vdout1_11ck940 FIND v(dout1_11) AT=950.05n

.meas tran vdout1_12ck940 FIND v(dout1_12) AT=950.05n

.meas tran vdout1_13ck940 FIND v(dout1_13) AT=950.05n

.meas tran vdout1_14ck940 FIND v(dout1_14) AT=950.05n

.meas tran vdout1_15ck940 FIND v(dout1_15) AT=950.05n

.meas tran vdout1_16ck940 FIND v(dout1_16) AT=950.05n

.meas tran vdout1_17ck940 FIND v(dout1_17) AT=950.05n

.meas tran vdout1_18ck940 FIND v(dout1_18) AT=950.05n

.meas tran vdout1_0ck960 FIND v(dout1_0) AT=970.05n

.meas tran vdout1_1ck960 FIND v(dout1_1) AT=970.05n

.meas tran vdout1_2ck960 FIND v(dout1_2) AT=970.05n

.meas tran vdout1_3ck960 FIND v(dout1_3) AT=970.05n

.meas tran vdout1_4ck960 FIND v(dout1_4) AT=970.05n

.meas tran vdout1_5ck960 FIND v(dout1_5) AT=970.05n

.meas tran vdout1_6ck960 FIND v(dout1_6) AT=970.05n

.meas tran vdout1_7ck960 FIND v(dout1_7) AT=970.05n

.meas tran vdout1_8ck960 FIND v(dout1_8) AT=970.05n

.meas tran vdout1_9ck960 FIND v(dout1_9) AT=970.05n

.meas tran vdout1_10ck960 FIND v(dout1_10) AT=970.05n

.meas tran vdout1_11ck960 FIND v(dout1_11) AT=970.05n

.meas tran vdout1_12ck960 FIND v(dout1_12) AT=970.05n

.meas tran vdout1_13ck960 FIND v(dout1_13) AT=970.05n

.meas tran vdout1_14ck960 FIND v(dout1_14) AT=970.05n

.meas tran vdout1_15ck960 FIND v(dout1_15) AT=970.05n

.meas tran vdout1_16ck960 FIND v(dout1_16) AT=970.05n

.meas tran vdout1_17ck960 FIND v(dout1_17) AT=970.05n

.meas tran vdout1_18ck960 FIND v(dout1_18) AT=970.05n

.meas tran vdout1_0ck990 FIND v(dout1_0) AT=1000.05n

.meas tran vdout1_1ck990 FIND v(dout1_1) AT=1000.05n

.meas tran vdout1_2ck990 FIND v(dout1_2) AT=1000.05n

.meas tran vdout1_3ck990 FIND v(dout1_3) AT=1000.05n

.meas tran vdout1_4ck990 FIND v(dout1_4) AT=1000.05n

.meas tran vdout1_5ck990 FIND v(dout1_5) AT=1000.05n

.meas tran vdout1_6ck990 FIND v(dout1_6) AT=1000.05n

.meas tran vdout1_7ck990 FIND v(dout1_7) AT=1000.05n

.meas tran vdout1_8ck990 FIND v(dout1_8) AT=1000.05n

.meas tran vdout1_9ck990 FIND v(dout1_9) AT=1000.05n

.meas tran vdout1_10ck990 FIND v(dout1_10) AT=1000.05n

.meas tran vdout1_11ck990 FIND v(dout1_11) AT=1000.05n

.meas tran vdout1_12ck990 FIND v(dout1_12) AT=1000.05n

.meas tran vdout1_13ck990 FIND v(dout1_13) AT=1000.05n

.meas tran vdout1_14ck990 FIND v(dout1_14) AT=1000.05n

.meas tran vdout1_15ck990 FIND v(dout1_15) AT=1000.05n

.meas tran vdout1_16ck990 FIND v(dout1_16) AT=1000.05n

.meas tran vdout1_17ck990 FIND v(dout1_17) AT=1000.05n

.meas tran vdout1_18ck990 FIND v(dout1_18) AT=1000.05n

.meas tran vdout1_0ck1000 FIND v(dout1_0) AT=1010.05n

.meas tran vdout1_1ck1000 FIND v(dout1_1) AT=1010.05n

.meas tran vdout1_2ck1000 FIND v(dout1_2) AT=1010.05n

.meas tran vdout1_3ck1000 FIND v(dout1_3) AT=1010.05n

.meas tran vdout1_4ck1000 FIND v(dout1_4) AT=1010.05n

.meas tran vdout1_5ck1000 FIND v(dout1_5) AT=1010.05n

.meas tran vdout1_6ck1000 FIND v(dout1_6) AT=1010.05n

.meas tran vdout1_7ck1000 FIND v(dout1_7) AT=1010.05n

.meas tran vdout1_8ck1000 FIND v(dout1_8) AT=1010.05n

.meas tran vdout1_9ck1000 FIND v(dout1_9) AT=1010.05n

.meas tran vdout1_10ck1000 FIND v(dout1_10) AT=1010.05n

.meas tran vdout1_11ck1000 FIND v(dout1_11) AT=1010.05n

.meas tran vdout1_12ck1000 FIND v(dout1_12) AT=1010.05n

.meas tran vdout1_13ck1000 FIND v(dout1_13) AT=1010.05n

.meas tran vdout1_14ck1000 FIND v(dout1_14) AT=1010.05n

.meas tran vdout1_15ck1000 FIND v(dout1_15) AT=1010.05n

.meas tran vdout1_16ck1000 FIND v(dout1_16) AT=1010.05n

.meas tran vdout1_17ck1000 FIND v(dout1_17) AT=1010.05n

.meas tran vdout1_18ck1000 FIND v(dout1_18) AT=1010.05n

.meas tran vdout1_0ck1040 FIND v(dout1_0) AT=1050.05n

.meas tran vdout1_1ck1040 FIND v(dout1_1) AT=1050.05n

.meas tran vdout1_2ck1040 FIND v(dout1_2) AT=1050.05n

.meas tran vdout1_3ck1040 FIND v(dout1_3) AT=1050.05n

.meas tran vdout1_4ck1040 FIND v(dout1_4) AT=1050.05n

.meas tran vdout1_5ck1040 FIND v(dout1_5) AT=1050.05n

.meas tran vdout1_6ck1040 FIND v(dout1_6) AT=1050.05n

.meas tran vdout1_7ck1040 FIND v(dout1_7) AT=1050.05n

.meas tran vdout1_8ck1040 FIND v(dout1_8) AT=1050.05n

.meas tran vdout1_9ck1040 FIND v(dout1_9) AT=1050.05n

.meas tran vdout1_10ck1040 FIND v(dout1_10) AT=1050.05n

.meas tran vdout1_11ck1040 FIND v(dout1_11) AT=1050.05n

.meas tran vdout1_12ck1040 FIND v(dout1_12) AT=1050.05n

.meas tran vdout1_13ck1040 FIND v(dout1_13) AT=1050.05n

.meas tran vdout1_14ck1040 FIND v(dout1_14) AT=1050.05n

.meas tran vdout1_15ck1040 FIND v(dout1_15) AT=1050.05n

.meas tran vdout1_16ck1040 FIND v(dout1_16) AT=1050.05n

.meas tran vdout1_17ck1040 FIND v(dout1_17) AT=1050.05n

.meas tran vdout1_18ck1040 FIND v(dout1_18) AT=1050.05n

.meas tran vdout1_0ck1060 FIND v(dout1_0) AT=1070.05n

.meas tran vdout1_1ck1060 FIND v(dout1_1) AT=1070.05n

.meas tran vdout1_2ck1060 FIND v(dout1_2) AT=1070.05n

.meas tran vdout1_3ck1060 FIND v(dout1_3) AT=1070.05n

.meas tran vdout1_4ck1060 FIND v(dout1_4) AT=1070.05n

.meas tran vdout1_5ck1060 FIND v(dout1_5) AT=1070.05n

.meas tran vdout1_6ck1060 FIND v(dout1_6) AT=1070.05n

.meas tran vdout1_7ck1060 FIND v(dout1_7) AT=1070.05n

.meas tran vdout1_8ck1060 FIND v(dout1_8) AT=1070.05n

.meas tran vdout1_9ck1060 FIND v(dout1_9) AT=1070.05n

.meas tran vdout1_10ck1060 FIND v(dout1_10) AT=1070.05n

.meas tran vdout1_11ck1060 FIND v(dout1_11) AT=1070.05n

.meas tran vdout1_12ck1060 FIND v(dout1_12) AT=1070.05n

.meas tran vdout1_13ck1060 FIND v(dout1_13) AT=1070.05n

.meas tran vdout1_14ck1060 FIND v(dout1_14) AT=1070.05n

.meas tran vdout1_15ck1060 FIND v(dout1_15) AT=1070.05n

.meas tran vdout1_16ck1060 FIND v(dout1_16) AT=1070.05n

.meas tran vdout1_17ck1060 FIND v(dout1_17) AT=1070.05n

.meas tran vdout1_18ck1060 FIND v(dout1_18) AT=1070.05n

.meas tran vdout1_0ck1110 FIND v(dout1_0) AT=1120.05n

.meas tran vdout1_1ck1110 FIND v(dout1_1) AT=1120.05n

.meas tran vdout1_2ck1110 FIND v(dout1_2) AT=1120.05n

.meas tran vdout1_3ck1110 FIND v(dout1_3) AT=1120.05n

.meas tran vdout1_4ck1110 FIND v(dout1_4) AT=1120.05n

.meas tran vdout1_5ck1110 FIND v(dout1_5) AT=1120.05n

.meas tran vdout1_6ck1110 FIND v(dout1_6) AT=1120.05n

.meas tran vdout1_7ck1110 FIND v(dout1_7) AT=1120.05n

.meas tran vdout1_8ck1110 FIND v(dout1_8) AT=1120.05n

.meas tran vdout1_9ck1110 FIND v(dout1_9) AT=1120.05n

.meas tran vdout1_10ck1110 FIND v(dout1_10) AT=1120.05n

.meas tran vdout1_11ck1110 FIND v(dout1_11) AT=1120.05n

.meas tran vdout1_12ck1110 FIND v(dout1_12) AT=1120.05n

.meas tran vdout1_13ck1110 FIND v(dout1_13) AT=1120.05n

.meas tran vdout1_14ck1110 FIND v(dout1_14) AT=1120.05n

.meas tran vdout1_15ck1110 FIND v(dout1_15) AT=1120.05n

.meas tran vdout1_16ck1110 FIND v(dout1_16) AT=1120.05n

.meas tran vdout1_17ck1110 FIND v(dout1_17) AT=1120.05n

.meas tran vdout1_18ck1110 FIND v(dout1_18) AT=1120.05n

.meas tran vdout1_0ck1120 FIND v(dout1_0) AT=1130.05n

.meas tran vdout1_1ck1120 FIND v(dout1_1) AT=1130.05n

.meas tran vdout1_2ck1120 FIND v(dout1_2) AT=1130.05n

.meas tran vdout1_3ck1120 FIND v(dout1_3) AT=1130.05n

.meas tran vdout1_4ck1120 FIND v(dout1_4) AT=1130.05n

.meas tran vdout1_5ck1120 FIND v(dout1_5) AT=1130.05n

.meas tran vdout1_6ck1120 FIND v(dout1_6) AT=1130.05n

.meas tran vdout1_7ck1120 FIND v(dout1_7) AT=1130.05n

.meas tran vdout1_8ck1120 FIND v(dout1_8) AT=1130.05n

.meas tran vdout1_9ck1120 FIND v(dout1_9) AT=1130.05n

.meas tran vdout1_10ck1120 FIND v(dout1_10) AT=1130.05n

.meas tran vdout1_11ck1120 FIND v(dout1_11) AT=1130.05n

.meas tran vdout1_12ck1120 FIND v(dout1_12) AT=1130.05n

.meas tran vdout1_13ck1120 FIND v(dout1_13) AT=1130.05n

.meas tran vdout1_14ck1120 FIND v(dout1_14) AT=1130.05n

.meas tran vdout1_15ck1120 FIND v(dout1_15) AT=1130.05n

.meas tran vdout1_16ck1120 FIND v(dout1_16) AT=1130.05n

.meas tran vdout1_17ck1120 FIND v(dout1_17) AT=1130.05n

.meas tran vdout1_18ck1120 FIND v(dout1_18) AT=1130.05n

.meas tran vdout1_0ck1130 FIND v(dout1_0) AT=1140.05n

.meas tran vdout1_1ck1130 FIND v(dout1_1) AT=1140.05n

.meas tran vdout1_2ck1130 FIND v(dout1_2) AT=1140.05n

.meas tran vdout1_3ck1130 FIND v(dout1_3) AT=1140.05n

.meas tran vdout1_4ck1130 FIND v(dout1_4) AT=1140.05n

.meas tran vdout1_5ck1130 FIND v(dout1_5) AT=1140.05n

.meas tran vdout1_6ck1130 FIND v(dout1_6) AT=1140.05n

.meas tran vdout1_7ck1130 FIND v(dout1_7) AT=1140.05n

.meas tran vdout1_8ck1130 FIND v(dout1_8) AT=1140.05n

.meas tran vdout1_9ck1130 FIND v(dout1_9) AT=1140.05n

.meas tran vdout1_10ck1130 FIND v(dout1_10) AT=1140.05n

.meas tran vdout1_11ck1130 FIND v(dout1_11) AT=1140.05n

.meas tran vdout1_12ck1130 FIND v(dout1_12) AT=1140.05n

.meas tran vdout1_13ck1130 FIND v(dout1_13) AT=1140.05n

.meas tran vdout1_14ck1130 FIND v(dout1_14) AT=1140.05n

.meas tran vdout1_15ck1130 FIND v(dout1_15) AT=1140.05n

.meas tran vdout1_16ck1130 FIND v(dout1_16) AT=1140.05n

.meas tran vdout1_17ck1130 FIND v(dout1_17) AT=1140.05n

.meas tran vdout1_18ck1130 FIND v(dout1_18) AT=1140.05n

.meas tran vdout1_0ck1170 FIND v(dout1_0) AT=1180.05n

.meas tran vdout1_1ck1170 FIND v(dout1_1) AT=1180.05n

.meas tran vdout1_2ck1170 FIND v(dout1_2) AT=1180.05n

.meas tran vdout1_3ck1170 FIND v(dout1_3) AT=1180.05n

.meas tran vdout1_4ck1170 FIND v(dout1_4) AT=1180.05n

.meas tran vdout1_5ck1170 FIND v(dout1_5) AT=1180.05n

.meas tran vdout1_6ck1170 FIND v(dout1_6) AT=1180.05n

.meas tran vdout1_7ck1170 FIND v(dout1_7) AT=1180.05n

.meas tran vdout1_8ck1170 FIND v(dout1_8) AT=1180.05n

.meas tran vdout1_9ck1170 FIND v(dout1_9) AT=1180.05n

.meas tran vdout1_10ck1170 FIND v(dout1_10) AT=1180.05n

.meas tran vdout1_11ck1170 FIND v(dout1_11) AT=1180.05n

.meas tran vdout1_12ck1170 FIND v(dout1_12) AT=1180.05n

.meas tran vdout1_13ck1170 FIND v(dout1_13) AT=1180.05n

.meas tran vdout1_14ck1170 FIND v(dout1_14) AT=1180.05n

.meas tran vdout1_15ck1170 FIND v(dout1_15) AT=1180.05n

.meas tran vdout1_16ck1170 FIND v(dout1_16) AT=1180.05n

.meas tran vdout1_17ck1170 FIND v(dout1_17) AT=1180.05n

.meas tran vdout1_18ck1170 FIND v(dout1_18) AT=1180.05n

.meas tran vdout1_0ck1200 FIND v(dout1_0) AT=1210.05n

.meas tran vdout1_1ck1200 FIND v(dout1_1) AT=1210.05n

.meas tran vdout1_2ck1200 FIND v(dout1_2) AT=1210.05n

.meas tran vdout1_3ck1200 FIND v(dout1_3) AT=1210.05n

.meas tran vdout1_4ck1200 FIND v(dout1_4) AT=1210.05n

.meas tran vdout1_5ck1200 FIND v(dout1_5) AT=1210.05n

.meas tran vdout1_6ck1200 FIND v(dout1_6) AT=1210.05n

.meas tran vdout1_7ck1200 FIND v(dout1_7) AT=1210.05n

.meas tran vdout1_8ck1200 FIND v(dout1_8) AT=1210.05n

.meas tran vdout1_9ck1200 FIND v(dout1_9) AT=1210.05n

.meas tran vdout1_10ck1200 FIND v(dout1_10) AT=1210.05n

.meas tran vdout1_11ck1200 FIND v(dout1_11) AT=1210.05n

.meas tran vdout1_12ck1200 FIND v(dout1_12) AT=1210.05n

.meas tran vdout1_13ck1200 FIND v(dout1_13) AT=1210.05n

.meas tran vdout1_14ck1200 FIND v(dout1_14) AT=1210.05n

.meas tran vdout1_15ck1200 FIND v(dout1_15) AT=1210.05n

.meas tran vdout1_16ck1200 FIND v(dout1_16) AT=1210.05n

.meas tran vdout1_17ck1200 FIND v(dout1_17) AT=1210.05n

.meas tran vdout1_18ck1200 FIND v(dout1_18) AT=1210.05n

.meas tran vdout1_0ck1210 FIND v(dout1_0) AT=1220.05n

.meas tran vdout1_1ck1210 FIND v(dout1_1) AT=1220.05n

.meas tran vdout1_2ck1210 FIND v(dout1_2) AT=1220.05n

.meas tran vdout1_3ck1210 FIND v(dout1_3) AT=1220.05n

.meas tran vdout1_4ck1210 FIND v(dout1_4) AT=1220.05n

.meas tran vdout1_5ck1210 FIND v(dout1_5) AT=1220.05n

.meas tran vdout1_6ck1210 FIND v(dout1_6) AT=1220.05n

.meas tran vdout1_7ck1210 FIND v(dout1_7) AT=1220.05n

.meas tran vdout1_8ck1210 FIND v(dout1_8) AT=1220.05n

.meas tran vdout1_9ck1210 FIND v(dout1_9) AT=1220.05n

.meas tran vdout1_10ck1210 FIND v(dout1_10) AT=1220.05n

.meas tran vdout1_11ck1210 FIND v(dout1_11) AT=1220.05n

.meas tran vdout1_12ck1210 FIND v(dout1_12) AT=1220.05n

.meas tran vdout1_13ck1210 FIND v(dout1_13) AT=1220.05n

.meas tran vdout1_14ck1210 FIND v(dout1_14) AT=1220.05n

.meas tran vdout1_15ck1210 FIND v(dout1_15) AT=1220.05n

.meas tran vdout1_16ck1210 FIND v(dout1_16) AT=1220.05n

.meas tran vdout1_17ck1210 FIND v(dout1_17) AT=1220.05n

.meas tran vdout1_18ck1210 FIND v(dout1_18) AT=1220.05n

.meas tran vdout1_0ck1220 FIND v(dout1_0) AT=1230.05n

.meas tran vdout1_1ck1220 FIND v(dout1_1) AT=1230.05n

.meas tran vdout1_2ck1220 FIND v(dout1_2) AT=1230.05n

.meas tran vdout1_3ck1220 FIND v(dout1_3) AT=1230.05n

.meas tran vdout1_4ck1220 FIND v(dout1_4) AT=1230.05n

.meas tran vdout1_5ck1220 FIND v(dout1_5) AT=1230.05n

.meas tran vdout1_6ck1220 FIND v(dout1_6) AT=1230.05n

.meas tran vdout1_7ck1220 FIND v(dout1_7) AT=1230.05n

.meas tran vdout1_8ck1220 FIND v(dout1_8) AT=1230.05n

.meas tran vdout1_9ck1220 FIND v(dout1_9) AT=1230.05n

.meas tran vdout1_10ck1220 FIND v(dout1_10) AT=1230.05n

.meas tran vdout1_11ck1220 FIND v(dout1_11) AT=1230.05n

.meas tran vdout1_12ck1220 FIND v(dout1_12) AT=1230.05n

.meas tran vdout1_13ck1220 FIND v(dout1_13) AT=1230.05n

.meas tran vdout1_14ck1220 FIND v(dout1_14) AT=1230.05n

.meas tran vdout1_15ck1220 FIND v(dout1_15) AT=1230.05n

.meas tran vdout1_16ck1220 FIND v(dout1_16) AT=1230.05n

.meas tran vdout1_17ck1220 FIND v(dout1_17) AT=1230.05n

.meas tran vdout1_18ck1220 FIND v(dout1_18) AT=1230.05n

.meas tran vdout1_0ck1250 FIND v(dout1_0) AT=1260.05n

.meas tran vdout1_1ck1250 FIND v(dout1_1) AT=1260.05n

.meas tran vdout1_2ck1250 FIND v(dout1_2) AT=1260.05n

.meas tran vdout1_3ck1250 FIND v(dout1_3) AT=1260.05n

.meas tran vdout1_4ck1250 FIND v(dout1_4) AT=1260.05n

.meas tran vdout1_5ck1250 FIND v(dout1_5) AT=1260.05n

.meas tran vdout1_6ck1250 FIND v(dout1_6) AT=1260.05n

.meas tran vdout1_7ck1250 FIND v(dout1_7) AT=1260.05n

.meas tran vdout1_8ck1250 FIND v(dout1_8) AT=1260.05n

.meas tran vdout1_9ck1250 FIND v(dout1_9) AT=1260.05n

.meas tran vdout1_10ck1250 FIND v(dout1_10) AT=1260.05n

.meas tran vdout1_11ck1250 FIND v(dout1_11) AT=1260.05n

.meas tran vdout1_12ck1250 FIND v(dout1_12) AT=1260.05n

.meas tran vdout1_13ck1250 FIND v(dout1_13) AT=1260.05n

.meas tran vdout1_14ck1250 FIND v(dout1_14) AT=1260.05n

.meas tran vdout1_15ck1250 FIND v(dout1_15) AT=1260.05n

.meas tran vdout1_16ck1250 FIND v(dout1_16) AT=1260.05n

.meas tran vdout1_17ck1250 FIND v(dout1_17) AT=1260.05n

.meas tran vdout1_18ck1250 FIND v(dout1_18) AT=1260.05n

.meas tran vdout1_0ck1260 FIND v(dout1_0) AT=1270.05n

.meas tran vdout1_1ck1260 FIND v(dout1_1) AT=1270.05n

.meas tran vdout1_2ck1260 FIND v(dout1_2) AT=1270.05n

.meas tran vdout1_3ck1260 FIND v(dout1_3) AT=1270.05n

.meas tran vdout1_4ck1260 FIND v(dout1_4) AT=1270.05n

.meas tran vdout1_5ck1260 FIND v(dout1_5) AT=1270.05n

.meas tran vdout1_6ck1260 FIND v(dout1_6) AT=1270.05n

.meas tran vdout1_7ck1260 FIND v(dout1_7) AT=1270.05n

.meas tran vdout1_8ck1260 FIND v(dout1_8) AT=1270.05n

.meas tran vdout1_9ck1260 FIND v(dout1_9) AT=1270.05n

.meas tran vdout1_10ck1260 FIND v(dout1_10) AT=1270.05n

.meas tran vdout1_11ck1260 FIND v(dout1_11) AT=1270.05n

.meas tran vdout1_12ck1260 FIND v(dout1_12) AT=1270.05n

.meas tran vdout1_13ck1260 FIND v(dout1_13) AT=1270.05n

.meas tran vdout1_14ck1260 FIND v(dout1_14) AT=1270.05n

.meas tran vdout1_15ck1260 FIND v(dout1_15) AT=1270.05n

.meas tran vdout1_16ck1260 FIND v(dout1_16) AT=1270.05n

.meas tran vdout1_17ck1260 FIND v(dout1_17) AT=1270.05n

.meas tran vdout1_18ck1260 FIND v(dout1_18) AT=1270.05n

.meas tran vdout1_0ck1310 FIND v(dout1_0) AT=1320.05n

.meas tran vdout1_1ck1310 FIND v(dout1_1) AT=1320.05n

.meas tran vdout1_2ck1310 FIND v(dout1_2) AT=1320.05n

.meas tran vdout1_3ck1310 FIND v(dout1_3) AT=1320.05n

.meas tran vdout1_4ck1310 FIND v(dout1_4) AT=1320.05n

.meas tran vdout1_5ck1310 FIND v(dout1_5) AT=1320.05n

.meas tran vdout1_6ck1310 FIND v(dout1_6) AT=1320.05n

.meas tran vdout1_7ck1310 FIND v(dout1_7) AT=1320.05n

.meas tran vdout1_8ck1310 FIND v(dout1_8) AT=1320.05n

.meas tran vdout1_9ck1310 FIND v(dout1_9) AT=1320.05n

.meas tran vdout1_10ck1310 FIND v(dout1_10) AT=1320.05n

.meas tran vdout1_11ck1310 FIND v(dout1_11) AT=1320.05n

.meas tran vdout1_12ck1310 FIND v(dout1_12) AT=1320.05n

.meas tran vdout1_13ck1310 FIND v(dout1_13) AT=1320.05n

.meas tran vdout1_14ck1310 FIND v(dout1_14) AT=1320.05n

.meas tran vdout1_15ck1310 FIND v(dout1_15) AT=1320.05n

.meas tran vdout1_16ck1310 FIND v(dout1_16) AT=1320.05n

.meas tran vdout1_17ck1310 FIND v(dout1_17) AT=1320.05n

.meas tran vdout1_18ck1310 FIND v(dout1_18) AT=1320.05n

.meas tran vdout1_0ck1330 FIND v(dout1_0) AT=1340.05n

.meas tran vdout1_1ck1330 FIND v(dout1_1) AT=1340.05n

.meas tran vdout1_2ck1330 FIND v(dout1_2) AT=1340.05n

.meas tran vdout1_3ck1330 FIND v(dout1_3) AT=1340.05n

.meas tran vdout1_4ck1330 FIND v(dout1_4) AT=1340.05n

.meas tran vdout1_5ck1330 FIND v(dout1_5) AT=1340.05n

.meas tran vdout1_6ck1330 FIND v(dout1_6) AT=1340.05n

.meas tran vdout1_7ck1330 FIND v(dout1_7) AT=1340.05n

.meas tran vdout1_8ck1330 FIND v(dout1_8) AT=1340.05n

.meas tran vdout1_9ck1330 FIND v(dout1_9) AT=1340.05n

.meas tran vdout1_10ck1330 FIND v(dout1_10) AT=1340.05n

.meas tran vdout1_11ck1330 FIND v(dout1_11) AT=1340.05n

.meas tran vdout1_12ck1330 FIND v(dout1_12) AT=1340.05n

.meas tran vdout1_13ck1330 FIND v(dout1_13) AT=1340.05n

.meas tran vdout1_14ck1330 FIND v(dout1_14) AT=1340.05n

.meas tran vdout1_15ck1330 FIND v(dout1_15) AT=1340.05n

.meas tran vdout1_16ck1330 FIND v(dout1_16) AT=1340.05n

.meas tran vdout1_17ck1330 FIND v(dout1_17) AT=1340.05n

.meas tran vdout1_18ck1330 FIND v(dout1_18) AT=1340.05n

.meas tran vdout1_0ck1340 FIND v(dout1_0) AT=1350.05n

.meas tran vdout1_1ck1340 FIND v(dout1_1) AT=1350.05n

.meas tran vdout1_2ck1340 FIND v(dout1_2) AT=1350.05n

.meas tran vdout1_3ck1340 FIND v(dout1_3) AT=1350.05n

.meas tran vdout1_4ck1340 FIND v(dout1_4) AT=1350.05n

.meas tran vdout1_5ck1340 FIND v(dout1_5) AT=1350.05n

.meas tran vdout1_6ck1340 FIND v(dout1_6) AT=1350.05n

.meas tran vdout1_7ck1340 FIND v(dout1_7) AT=1350.05n

.meas tran vdout1_8ck1340 FIND v(dout1_8) AT=1350.05n

.meas tran vdout1_9ck1340 FIND v(dout1_9) AT=1350.05n

.meas tran vdout1_10ck1340 FIND v(dout1_10) AT=1350.05n

.meas tran vdout1_11ck1340 FIND v(dout1_11) AT=1350.05n

.meas tran vdout1_12ck1340 FIND v(dout1_12) AT=1350.05n

.meas tran vdout1_13ck1340 FIND v(dout1_13) AT=1350.05n

.meas tran vdout1_14ck1340 FIND v(dout1_14) AT=1350.05n

.meas tran vdout1_15ck1340 FIND v(dout1_15) AT=1350.05n

.meas tran vdout1_16ck1340 FIND v(dout1_16) AT=1350.05n

.meas tran vdout1_17ck1340 FIND v(dout1_17) AT=1350.05n

.meas tran vdout1_18ck1340 FIND v(dout1_18) AT=1350.05n

.meas tran vdout1_0ck1350 FIND v(dout1_0) AT=1360.05n

.meas tran vdout1_1ck1350 FIND v(dout1_1) AT=1360.05n

.meas tran vdout1_2ck1350 FIND v(dout1_2) AT=1360.05n

.meas tran vdout1_3ck1350 FIND v(dout1_3) AT=1360.05n

.meas tran vdout1_4ck1350 FIND v(dout1_4) AT=1360.05n

.meas tran vdout1_5ck1350 FIND v(dout1_5) AT=1360.05n

.meas tran vdout1_6ck1350 FIND v(dout1_6) AT=1360.05n

.meas tran vdout1_7ck1350 FIND v(dout1_7) AT=1360.05n

.meas tran vdout1_8ck1350 FIND v(dout1_8) AT=1360.05n

.meas tran vdout1_9ck1350 FIND v(dout1_9) AT=1360.05n

.meas tran vdout1_10ck1350 FIND v(dout1_10) AT=1360.05n

.meas tran vdout1_11ck1350 FIND v(dout1_11) AT=1360.05n

.meas tran vdout1_12ck1350 FIND v(dout1_12) AT=1360.05n

.meas tran vdout1_13ck1350 FIND v(dout1_13) AT=1360.05n

.meas tran vdout1_14ck1350 FIND v(dout1_14) AT=1360.05n

.meas tran vdout1_15ck1350 FIND v(dout1_15) AT=1360.05n

.meas tran vdout1_16ck1350 FIND v(dout1_16) AT=1360.05n

.meas tran vdout1_17ck1350 FIND v(dout1_17) AT=1360.05n

.meas tran vdout1_18ck1350 FIND v(dout1_18) AT=1360.05n

.meas tran vdout1_0ck1360 FIND v(dout1_0) AT=1370.05n

.meas tran vdout1_1ck1360 FIND v(dout1_1) AT=1370.05n

.meas tran vdout1_2ck1360 FIND v(dout1_2) AT=1370.05n

.meas tran vdout1_3ck1360 FIND v(dout1_3) AT=1370.05n

.meas tran vdout1_4ck1360 FIND v(dout1_4) AT=1370.05n

.meas tran vdout1_5ck1360 FIND v(dout1_5) AT=1370.05n

.meas tran vdout1_6ck1360 FIND v(dout1_6) AT=1370.05n

.meas tran vdout1_7ck1360 FIND v(dout1_7) AT=1370.05n

.meas tran vdout1_8ck1360 FIND v(dout1_8) AT=1370.05n

.meas tran vdout1_9ck1360 FIND v(dout1_9) AT=1370.05n

.meas tran vdout1_10ck1360 FIND v(dout1_10) AT=1370.05n

.meas tran vdout1_11ck1360 FIND v(dout1_11) AT=1370.05n

.meas tran vdout1_12ck1360 FIND v(dout1_12) AT=1370.05n

.meas tran vdout1_13ck1360 FIND v(dout1_13) AT=1370.05n

.meas tran vdout1_14ck1360 FIND v(dout1_14) AT=1370.05n

.meas tran vdout1_15ck1360 FIND v(dout1_15) AT=1370.05n

.meas tran vdout1_16ck1360 FIND v(dout1_16) AT=1370.05n

.meas tran vdout1_17ck1360 FIND v(dout1_17) AT=1370.05n

.meas tran vdout1_18ck1360 FIND v(dout1_18) AT=1370.05n

.meas tran vdout1_0ck1370 FIND v(dout1_0) AT=1380.05n

.meas tran vdout1_1ck1370 FIND v(dout1_1) AT=1380.05n

.meas tran vdout1_2ck1370 FIND v(dout1_2) AT=1380.05n

.meas tran vdout1_3ck1370 FIND v(dout1_3) AT=1380.05n

.meas tran vdout1_4ck1370 FIND v(dout1_4) AT=1380.05n

.meas tran vdout1_5ck1370 FIND v(dout1_5) AT=1380.05n

.meas tran vdout1_6ck1370 FIND v(dout1_6) AT=1380.05n

.meas tran vdout1_7ck1370 FIND v(dout1_7) AT=1380.05n

.meas tran vdout1_8ck1370 FIND v(dout1_8) AT=1380.05n

.meas tran vdout1_9ck1370 FIND v(dout1_9) AT=1380.05n

.meas tran vdout1_10ck1370 FIND v(dout1_10) AT=1380.05n

.meas tran vdout1_11ck1370 FIND v(dout1_11) AT=1380.05n

.meas tran vdout1_12ck1370 FIND v(dout1_12) AT=1380.05n

.meas tran vdout1_13ck1370 FIND v(dout1_13) AT=1380.05n

.meas tran vdout1_14ck1370 FIND v(dout1_14) AT=1380.05n

.meas tran vdout1_15ck1370 FIND v(dout1_15) AT=1380.05n

.meas tran vdout1_16ck1370 FIND v(dout1_16) AT=1380.05n

.meas tran vdout1_17ck1370 FIND v(dout1_17) AT=1380.05n

.meas tran vdout1_18ck1370 FIND v(dout1_18) AT=1380.05n

.meas tran vdout1_0ck1390 FIND v(dout1_0) AT=1400.05n

.meas tran vdout1_1ck1390 FIND v(dout1_1) AT=1400.05n

.meas tran vdout1_2ck1390 FIND v(dout1_2) AT=1400.05n

.meas tran vdout1_3ck1390 FIND v(dout1_3) AT=1400.05n

.meas tran vdout1_4ck1390 FIND v(dout1_4) AT=1400.05n

.meas tran vdout1_5ck1390 FIND v(dout1_5) AT=1400.05n

.meas tran vdout1_6ck1390 FIND v(dout1_6) AT=1400.05n

.meas tran vdout1_7ck1390 FIND v(dout1_7) AT=1400.05n

.meas tran vdout1_8ck1390 FIND v(dout1_8) AT=1400.05n

.meas tran vdout1_9ck1390 FIND v(dout1_9) AT=1400.05n

.meas tran vdout1_10ck1390 FIND v(dout1_10) AT=1400.05n

.meas tran vdout1_11ck1390 FIND v(dout1_11) AT=1400.05n

.meas tran vdout1_12ck1390 FIND v(dout1_12) AT=1400.05n

.meas tran vdout1_13ck1390 FIND v(dout1_13) AT=1400.05n

.meas tran vdout1_14ck1390 FIND v(dout1_14) AT=1400.05n

.meas tran vdout1_15ck1390 FIND v(dout1_15) AT=1400.05n

.meas tran vdout1_16ck1390 FIND v(dout1_16) AT=1400.05n

.meas tran vdout1_17ck1390 FIND v(dout1_17) AT=1400.05n

.meas tran vdout1_18ck1390 FIND v(dout1_18) AT=1400.05n

.meas tran vdout1_0ck1400 FIND v(dout1_0) AT=1410.05n

.meas tran vdout1_1ck1400 FIND v(dout1_1) AT=1410.05n

.meas tran vdout1_2ck1400 FIND v(dout1_2) AT=1410.05n

.meas tran vdout1_3ck1400 FIND v(dout1_3) AT=1410.05n

.meas tran vdout1_4ck1400 FIND v(dout1_4) AT=1410.05n

.meas tran vdout1_5ck1400 FIND v(dout1_5) AT=1410.05n

.meas tran vdout1_6ck1400 FIND v(dout1_6) AT=1410.05n

.meas tran vdout1_7ck1400 FIND v(dout1_7) AT=1410.05n

.meas tran vdout1_8ck1400 FIND v(dout1_8) AT=1410.05n

.meas tran vdout1_9ck1400 FIND v(dout1_9) AT=1410.05n

.meas tran vdout1_10ck1400 FIND v(dout1_10) AT=1410.05n

.meas tran vdout1_11ck1400 FIND v(dout1_11) AT=1410.05n

.meas tran vdout1_12ck1400 FIND v(dout1_12) AT=1410.05n

.meas tran vdout1_13ck1400 FIND v(dout1_13) AT=1410.05n

.meas tran vdout1_14ck1400 FIND v(dout1_14) AT=1410.05n

.meas tran vdout1_15ck1400 FIND v(dout1_15) AT=1410.05n

.meas tran vdout1_16ck1400 FIND v(dout1_16) AT=1410.05n

.meas tran vdout1_17ck1400 FIND v(dout1_17) AT=1410.05n

.meas tran vdout1_18ck1400 FIND v(dout1_18) AT=1410.05n

.meas tran vdout1_0ck1410 FIND v(dout1_0) AT=1420.05n

.meas tran vdout1_1ck1410 FIND v(dout1_1) AT=1420.05n

.meas tran vdout1_2ck1410 FIND v(dout1_2) AT=1420.05n

.meas tran vdout1_3ck1410 FIND v(dout1_3) AT=1420.05n

.meas tran vdout1_4ck1410 FIND v(dout1_4) AT=1420.05n

.meas tran vdout1_5ck1410 FIND v(dout1_5) AT=1420.05n

.meas tran vdout1_6ck1410 FIND v(dout1_6) AT=1420.05n

.meas tran vdout1_7ck1410 FIND v(dout1_7) AT=1420.05n

.meas tran vdout1_8ck1410 FIND v(dout1_8) AT=1420.05n

.meas tran vdout1_9ck1410 FIND v(dout1_9) AT=1420.05n

.meas tran vdout1_10ck1410 FIND v(dout1_10) AT=1420.05n

.meas tran vdout1_11ck1410 FIND v(dout1_11) AT=1420.05n

.meas tran vdout1_12ck1410 FIND v(dout1_12) AT=1420.05n

.meas tran vdout1_13ck1410 FIND v(dout1_13) AT=1420.05n

.meas tran vdout1_14ck1410 FIND v(dout1_14) AT=1420.05n

.meas tran vdout1_15ck1410 FIND v(dout1_15) AT=1420.05n

.meas tran vdout1_16ck1410 FIND v(dout1_16) AT=1420.05n

.meas tran vdout1_17ck1410 FIND v(dout1_17) AT=1420.05n

.meas tran vdout1_18ck1410 FIND v(dout1_18) AT=1420.05n

.meas tran vdout1_0ck1460 FIND v(dout1_0) AT=1470.05n

.meas tran vdout1_1ck1460 FIND v(dout1_1) AT=1470.05n

.meas tran vdout1_2ck1460 FIND v(dout1_2) AT=1470.05n

.meas tran vdout1_3ck1460 FIND v(dout1_3) AT=1470.05n

.meas tran vdout1_4ck1460 FIND v(dout1_4) AT=1470.05n

.meas tran vdout1_5ck1460 FIND v(dout1_5) AT=1470.05n

.meas tran vdout1_6ck1460 FIND v(dout1_6) AT=1470.05n

.meas tran vdout1_7ck1460 FIND v(dout1_7) AT=1470.05n

.meas tran vdout1_8ck1460 FIND v(dout1_8) AT=1470.05n

.meas tran vdout1_9ck1460 FIND v(dout1_9) AT=1470.05n

.meas tran vdout1_10ck1460 FIND v(dout1_10) AT=1470.05n

.meas tran vdout1_11ck1460 FIND v(dout1_11) AT=1470.05n

.meas tran vdout1_12ck1460 FIND v(dout1_12) AT=1470.05n

.meas tran vdout1_13ck1460 FIND v(dout1_13) AT=1470.05n

.meas tran vdout1_14ck1460 FIND v(dout1_14) AT=1470.05n

.meas tran vdout1_15ck1460 FIND v(dout1_15) AT=1470.05n

.meas tran vdout1_16ck1460 FIND v(dout1_16) AT=1470.05n

.meas tran vdout1_17ck1460 FIND v(dout1_17) AT=1470.05n

.meas tran vdout1_18ck1460 FIND v(dout1_18) AT=1470.05n

.meas tran vdout1_0ck1470 FIND v(dout1_0) AT=1480.05n

.meas tran vdout1_1ck1470 FIND v(dout1_1) AT=1480.05n

.meas tran vdout1_2ck1470 FIND v(dout1_2) AT=1480.05n

.meas tran vdout1_3ck1470 FIND v(dout1_3) AT=1480.05n

.meas tran vdout1_4ck1470 FIND v(dout1_4) AT=1480.05n

.meas tran vdout1_5ck1470 FIND v(dout1_5) AT=1480.05n

.meas tran vdout1_6ck1470 FIND v(dout1_6) AT=1480.05n

.meas tran vdout1_7ck1470 FIND v(dout1_7) AT=1480.05n

.meas tran vdout1_8ck1470 FIND v(dout1_8) AT=1480.05n

.meas tran vdout1_9ck1470 FIND v(dout1_9) AT=1480.05n

.meas tran vdout1_10ck1470 FIND v(dout1_10) AT=1480.05n

.meas tran vdout1_11ck1470 FIND v(dout1_11) AT=1480.05n

.meas tran vdout1_12ck1470 FIND v(dout1_12) AT=1480.05n

.meas tran vdout1_13ck1470 FIND v(dout1_13) AT=1480.05n

.meas tran vdout1_14ck1470 FIND v(dout1_14) AT=1480.05n

.meas tran vdout1_15ck1470 FIND v(dout1_15) AT=1480.05n

.meas tran vdout1_16ck1470 FIND v(dout1_16) AT=1480.05n

.meas tran vdout1_17ck1470 FIND v(dout1_17) AT=1480.05n

.meas tran vdout1_18ck1470 FIND v(dout1_18) AT=1480.05n

.meas tran vdout1_0ck1520 FIND v(dout1_0) AT=1530.05n

.meas tran vdout1_1ck1520 FIND v(dout1_1) AT=1530.05n

.meas tran vdout1_2ck1520 FIND v(dout1_2) AT=1530.05n

.meas tran vdout1_3ck1520 FIND v(dout1_3) AT=1530.05n

.meas tran vdout1_4ck1520 FIND v(dout1_4) AT=1530.05n

.meas tran vdout1_5ck1520 FIND v(dout1_5) AT=1530.05n

.meas tran vdout1_6ck1520 FIND v(dout1_6) AT=1530.05n

.meas tran vdout1_7ck1520 FIND v(dout1_7) AT=1530.05n

.meas tran vdout1_8ck1520 FIND v(dout1_8) AT=1530.05n

.meas tran vdout1_9ck1520 FIND v(dout1_9) AT=1530.05n

.meas tran vdout1_10ck1520 FIND v(dout1_10) AT=1530.05n

.meas tran vdout1_11ck1520 FIND v(dout1_11) AT=1530.05n

.meas tran vdout1_12ck1520 FIND v(dout1_12) AT=1530.05n

.meas tran vdout1_13ck1520 FIND v(dout1_13) AT=1530.05n

.meas tran vdout1_14ck1520 FIND v(dout1_14) AT=1530.05n

.meas tran vdout1_15ck1520 FIND v(dout1_15) AT=1530.05n

.meas tran vdout1_16ck1520 FIND v(dout1_16) AT=1530.05n

.meas tran vdout1_17ck1520 FIND v(dout1_17) AT=1530.05n

.meas tran vdout1_18ck1520 FIND v(dout1_18) AT=1530.05n

.meas tran vdout1_0ck1530 FIND v(dout1_0) AT=1540.05n

.meas tran vdout1_1ck1530 FIND v(dout1_1) AT=1540.05n

.meas tran vdout1_2ck1530 FIND v(dout1_2) AT=1540.05n

.meas tran vdout1_3ck1530 FIND v(dout1_3) AT=1540.05n

.meas tran vdout1_4ck1530 FIND v(dout1_4) AT=1540.05n

.meas tran vdout1_5ck1530 FIND v(dout1_5) AT=1540.05n

.meas tran vdout1_6ck1530 FIND v(dout1_6) AT=1540.05n

.meas tran vdout1_7ck1530 FIND v(dout1_7) AT=1540.05n

.meas tran vdout1_8ck1530 FIND v(dout1_8) AT=1540.05n

.meas tran vdout1_9ck1530 FIND v(dout1_9) AT=1540.05n

.meas tran vdout1_10ck1530 FIND v(dout1_10) AT=1540.05n

.meas tran vdout1_11ck1530 FIND v(dout1_11) AT=1540.05n

.meas tran vdout1_12ck1530 FIND v(dout1_12) AT=1540.05n

.meas tran vdout1_13ck1530 FIND v(dout1_13) AT=1540.05n

.meas tran vdout1_14ck1530 FIND v(dout1_14) AT=1540.05n

.meas tran vdout1_15ck1530 FIND v(dout1_15) AT=1540.05n

.meas tran vdout1_16ck1530 FIND v(dout1_16) AT=1540.05n

.meas tran vdout1_17ck1530 FIND v(dout1_17) AT=1540.05n

.meas tran vdout1_18ck1530 FIND v(dout1_18) AT=1540.05n

.meas tran vdout1_0ck1560 FIND v(dout1_0) AT=1570.05n

.meas tran vdout1_1ck1560 FIND v(dout1_1) AT=1570.05n

.meas tran vdout1_2ck1560 FIND v(dout1_2) AT=1570.05n

.meas tran vdout1_3ck1560 FIND v(dout1_3) AT=1570.05n

.meas tran vdout1_4ck1560 FIND v(dout1_4) AT=1570.05n

.meas tran vdout1_5ck1560 FIND v(dout1_5) AT=1570.05n

.meas tran vdout1_6ck1560 FIND v(dout1_6) AT=1570.05n

.meas tran vdout1_7ck1560 FIND v(dout1_7) AT=1570.05n

.meas tran vdout1_8ck1560 FIND v(dout1_8) AT=1570.05n

.meas tran vdout1_9ck1560 FIND v(dout1_9) AT=1570.05n

.meas tran vdout1_10ck1560 FIND v(dout1_10) AT=1570.05n

.meas tran vdout1_11ck1560 FIND v(dout1_11) AT=1570.05n

.meas tran vdout1_12ck1560 FIND v(dout1_12) AT=1570.05n

.meas tran vdout1_13ck1560 FIND v(dout1_13) AT=1570.05n

.meas tran vdout1_14ck1560 FIND v(dout1_14) AT=1570.05n

.meas tran vdout1_15ck1560 FIND v(dout1_15) AT=1570.05n

.meas tran vdout1_16ck1560 FIND v(dout1_16) AT=1570.05n

.meas tran vdout1_17ck1560 FIND v(dout1_17) AT=1570.05n

.meas tran vdout1_18ck1560 FIND v(dout1_18) AT=1570.05n

.meas tran vdout1_0ck1570 FIND v(dout1_0) AT=1580.05n

.meas tran vdout1_1ck1570 FIND v(dout1_1) AT=1580.05n

.meas tran vdout1_2ck1570 FIND v(dout1_2) AT=1580.05n

.meas tran vdout1_3ck1570 FIND v(dout1_3) AT=1580.05n

.meas tran vdout1_4ck1570 FIND v(dout1_4) AT=1580.05n

.meas tran vdout1_5ck1570 FIND v(dout1_5) AT=1580.05n

.meas tran vdout1_6ck1570 FIND v(dout1_6) AT=1580.05n

.meas tran vdout1_7ck1570 FIND v(dout1_7) AT=1580.05n

.meas tran vdout1_8ck1570 FIND v(dout1_8) AT=1580.05n

.meas tran vdout1_9ck1570 FIND v(dout1_9) AT=1580.05n

.meas tran vdout1_10ck1570 FIND v(dout1_10) AT=1580.05n

.meas tran vdout1_11ck1570 FIND v(dout1_11) AT=1580.05n

.meas tran vdout1_12ck1570 FIND v(dout1_12) AT=1580.05n

.meas tran vdout1_13ck1570 FIND v(dout1_13) AT=1580.05n

.meas tran vdout1_14ck1570 FIND v(dout1_14) AT=1580.05n

.meas tran vdout1_15ck1570 FIND v(dout1_15) AT=1580.05n

.meas tran vdout1_16ck1570 FIND v(dout1_16) AT=1580.05n

.meas tran vdout1_17ck1570 FIND v(dout1_17) AT=1580.05n

.meas tran vdout1_18ck1570 FIND v(dout1_18) AT=1580.05n

.meas tran vdout1_0ck1630 FIND v(dout1_0) AT=1640.05n

.meas tran vdout1_1ck1630 FIND v(dout1_1) AT=1640.05n

.meas tran vdout1_2ck1630 FIND v(dout1_2) AT=1640.05n

.meas tran vdout1_3ck1630 FIND v(dout1_3) AT=1640.05n

.meas tran vdout1_4ck1630 FIND v(dout1_4) AT=1640.05n

.meas tran vdout1_5ck1630 FIND v(dout1_5) AT=1640.05n

.meas tran vdout1_6ck1630 FIND v(dout1_6) AT=1640.05n

.meas tran vdout1_7ck1630 FIND v(dout1_7) AT=1640.05n

.meas tran vdout1_8ck1630 FIND v(dout1_8) AT=1640.05n

.meas tran vdout1_9ck1630 FIND v(dout1_9) AT=1640.05n

.meas tran vdout1_10ck1630 FIND v(dout1_10) AT=1640.05n

.meas tran vdout1_11ck1630 FIND v(dout1_11) AT=1640.05n

.meas tran vdout1_12ck1630 FIND v(dout1_12) AT=1640.05n

.meas tran vdout1_13ck1630 FIND v(dout1_13) AT=1640.05n

.meas tran vdout1_14ck1630 FIND v(dout1_14) AT=1640.05n

.meas tran vdout1_15ck1630 FIND v(dout1_15) AT=1640.05n

.meas tran vdout1_16ck1630 FIND v(dout1_16) AT=1640.05n

.meas tran vdout1_17ck1630 FIND v(dout1_17) AT=1640.05n

.meas tran vdout1_18ck1630 FIND v(dout1_18) AT=1640.05n

.meas tran vdout1_0ck1670 FIND v(dout1_0) AT=1680.05n

.meas tran vdout1_1ck1670 FIND v(dout1_1) AT=1680.05n

.meas tran vdout1_2ck1670 FIND v(dout1_2) AT=1680.05n

.meas tran vdout1_3ck1670 FIND v(dout1_3) AT=1680.05n

.meas tran vdout1_4ck1670 FIND v(dout1_4) AT=1680.05n

.meas tran vdout1_5ck1670 FIND v(dout1_5) AT=1680.05n

.meas tran vdout1_6ck1670 FIND v(dout1_6) AT=1680.05n

.meas tran vdout1_7ck1670 FIND v(dout1_7) AT=1680.05n

.meas tran vdout1_8ck1670 FIND v(dout1_8) AT=1680.05n

.meas tran vdout1_9ck1670 FIND v(dout1_9) AT=1680.05n

.meas tran vdout1_10ck1670 FIND v(dout1_10) AT=1680.05n

.meas tran vdout1_11ck1670 FIND v(dout1_11) AT=1680.05n

.meas tran vdout1_12ck1670 FIND v(dout1_12) AT=1680.05n

.meas tran vdout1_13ck1670 FIND v(dout1_13) AT=1680.05n

.meas tran vdout1_14ck1670 FIND v(dout1_14) AT=1680.05n

.meas tran vdout1_15ck1670 FIND v(dout1_15) AT=1680.05n

.meas tran vdout1_16ck1670 FIND v(dout1_16) AT=1680.05n

.meas tran vdout1_17ck1670 FIND v(dout1_17) AT=1680.05n

.meas tran vdout1_18ck1670 FIND v(dout1_18) AT=1680.05n

.meas tran vdout1_0ck1680 FIND v(dout1_0) AT=1690.05n

.meas tran vdout1_1ck1680 FIND v(dout1_1) AT=1690.05n

.meas tran vdout1_2ck1680 FIND v(dout1_2) AT=1690.05n

.meas tran vdout1_3ck1680 FIND v(dout1_3) AT=1690.05n

.meas tran vdout1_4ck1680 FIND v(dout1_4) AT=1690.05n

.meas tran vdout1_5ck1680 FIND v(dout1_5) AT=1690.05n

.meas tran vdout1_6ck1680 FIND v(dout1_6) AT=1690.05n

.meas tran vdout1_7ck1680 FIND v(dout1_7) AT=1690.05n

.meas tran vdout1_8ck1680 FIND v(dout1_8) AT=1690.05n

.meas tran vdout1_9ck1680 FIND v(dout1_9) AT=1690.05n

.meas tran vdout1_10ck1680 FIND v(dout1_10) AT=1690.05n

.meas tran vdout1_11ck1680 FIND v(dout1_11) AT=1690.05n

.meas tran vdout1_12ck1680 FIND v(dout1_12) AT=1690.05n

.meas tran vdout1_13ck1680 FIND v(dout1_13) AT=1690.05n

.meas tran vdout1_14ck1680 FIND v(dout1_14) AT=1690.05n

.meas tran vdout1_15ck1680 FIND v(dout1_15) AT=1690.05n

.meas tran vdout1_16ck1680 FIND v(dout1_16) AT=1690.05n

.meas tran vdout1_17ck1680 FIND v(dout1_17) AT=1690.05n

.meas tran vdout1_18ck1680 FIND v(dout1_18) AT=1690.05n

.meas tran vdout1_0ck1690 FIND v(dout1_0) AT=1700.05n

.meas tran vdout1_1ck1690 FIND v(dout1_1) AT=1700.05n

.meas tran vdout1_2ck1690 FIND v(dout1_2) AT=1700.05n

.meas tran vdout1_3ck1690 FIND v(dout1_3) AT=1700.05n

.meas tran vdout1_4ck1690 FIND v(dout1_4) AT=1700.05n

.meas tran vdout1_5ck1690 FIND v(dout1_5) AT=1700.05n

.meas tran vdout1_6ck1690 FIND v(dout1_6) AT=1700.05n

.meas tran vdout1_7ck1690 FIND v(dout1_7) AT=1700.05n

.meas tran vdout1_8ck1690 FIND v(dout1_8) AT=1700.05n

.meas tran vdout1_9ck1690 FIND v(dout1_9) AT=1700.05n

.meas tran vdout1_10ck1690 FIND v(dout1_10) AT=1700.05n

.meas tran vdout1_11ck1690 FIND v(dout1_11) AT=1700.05n

.meas tran vdout1_12ck1690 FIND v(dout1_12) AT=1700.05n

.meas tran vdout1_13ck1690 FIND v(dout1_13) AT=1700.05n

.meas tran vdout1_14ck1690 FIND v(dout1_14) AT=1700.05n

.meas tran vdout1_15ck1690 FIND v(dout1_15) AT=1700.05n

.meas tran vdout1_16ck1690 FIND v(dout1_16) AT=1700.05n

.meas tran vdout1_17ck1690 FIND v(dout1_17) AT=1700.05n

.meas tran vdout1_18ck1690 FIND v(dout1_18) AT=1700.05n

.meas tran vdout1_0ck1740 FIND v(dout1_0) AT=1750.05n

.meas tran vdout1_1ck1740 FIND v(dout1_1) AT=1750.05n

.meas tran vdout1_2ck1740 FIND v(dout1_2) AT=1750.05n

.meas tran vdout1_3ck1740 FIND v(dout1_3) AT=1750.05n

.meas tran vdout1_4ck1740 FIND v(dout1_4) AT=1750.05n

.meas tran vdout1_5ck1740 FIND v(dout1_5) AT=1750.05n

.meas tran vdout1_6ck1740 FIND v(dout1_6) AT=1750.05n

.meas tran vdout1_7ck1740 FIND v(dout1_7) AT=1750.05n

.meas tran vdout1_8ck1740 FIND v(dout1_8) AT=1750.05n

.meas tran vdout1_9ck1740 FIND v(dout1_9) AT=1750.05n

.meas tran vdout1_10ck1740 FIND v(dout1_10) AT=1750.05n

.meas tran vdout1_11ck1740 FIND v(dout1_11) AT=1750.05n

.meas tran vdout1_12ck1740 FIND v(dout1_12) AT=1750.05n

.meas tran vdout1_13ck1740 FIND v(dout1_13) AT=1750.05n

.meas tran vdout1_14ck1740 FIND v(dout1_14) AT=1750.05n

.meas tran vdout1_15ck1740 FIND v(dout1_15) AT=1750.05n

.meas tran vdout1_16ck1740 FIND v(dout1_16) AT=1750.05n

.meas tran vdout1_17ck1740 FIND v(dout1_17) AT=1750.05n

.meas tran vdout1_18ck1740 FIND v(dout1_18) AT=1750.05n

.meas tran vdout1_0ck1760 FIND v(dout1_0) AT=1770.05n

.meas tran vdout1_1ck1760 FIND v(dout1_1) AT=1770.05n

.meas tran vdout1_2ck1760 FIND v(dout1_2) AT=1770.05n

.meas tran vdout1_3ck1760 FIND v(dout1_3) AT=1770.05n

.meas tran vdout1_4ck1760 FIND v(dout1_4) AT=1770.05n

.meas tran vdout1_5ck1760 FIND v(dout1_5) AT=1770.05n

.meas tran vdout1_6ck1760 FIND v(dout1_6) AT=1770.05n

.meas tran vdout1_7ck1760 FIND v(dout1_7) AT=1770.05n

.meas tran vdout1_8ck1760 FIND v(dout1_8) AT=1770.05n

.meas tran vdout1_9ck1760 FIND v(dout1_9) AT=1770.05n

.meas tran vdout1_10ck1760 FIND v(dout1_10) AT=1770.05n

.meas tran vdout1_11ck1760 FIND v(dout1_11) AT=1770.05n

.meas tran vdout1_12ck1760 FIND v(dout1_12) AT=1770.05n

.meas tran vdout1_13ck1760 FIND v(dout1_13) AT=1770.05n

.meas tran vdout1_14ck1760 FIND v(dout1_14) AT=1770.05n

.meas tran vdout1_15ck1760 FIND v(dout1_15) AT=1770.05n

.meas tran vdout1_16ck1760 FIND v(dout1_16) AT=1770.05n

.meas tran vdout1_17ck1760 FIND v(dout1_17) AT=1770.05n

.meas tran vdout1_18ck1760 FIND v(dout1_18) AT=1770.05n

.meas tran vdout1_0ck1770 FIND v(dout1_0) AT=1780.05n

.meas tran vdout1_1ck1770 FIND v(dout1_1) AT=1780.05n

.meas tran vdout1_2ck1770 FIND v(dout1_2) AT=1780.05n

.meas tran vdout1_3ck1770 FIND v(dout1_3) AT=1780.05n

.meas tran vdout1_4ck1770 FIND v(dout1_4) AT=1780.05n

.meas tran vdout1_5ck1770 FIND v(dout1_5) AT=1780.05n

.meas tran vdout1_6ck1770 FIND v(dout1_6) AT=1780.05n

.meas tran vdout1_7ck1770 FIND v(dout1_7) AT=1780.05n

.meas tran vdout1_8ck1770 FIND v(dout1_8) AT=1780.05n

.meas tran vdout1_9ck1770 FIND v(dout1_9) AT=1780.05n

.meas tran vdout1_10ck1770 FIND v(dout1_10) AT=1780.05n

.meas tran vdout1_11ck1770 FIND v(dout1_11) AT=1780.05n

.meas tran vdout1_12ck1770 FIND v(dout1_12) AT=1780.05n

.meas tran vdout1_13ck1770 FIND v(dout1_13) AT=1780.05n

.meas tran vdout1_14ck1770 FIND v(dout1_14) AT=1780.05n

.meas tran vdout1_15ck1770 FIND v(dout1_15) AT=1780.05n

.meas tran vdout1_16ck1770 FIND v(dout1_16) AT=1780.05n

.meas tran vdout1_17ck1770 FIND v(dout1_17) AT=1780.05n

.meas tran vdout1_18ck1770 FIND v(dout1_18) AT=1780.05n

.meas tran vdout1_0ck1830 FIND v(dout1_0) AT=1840.05n

.meas tran vdout1_1ck1830 FIND v(dout1_1) AT=1840.05n

.meas tran vdout1_2ck1830 FIND v(dout1_2) AT=1840.05n

.meas tran vdout1_3ck1830 FIND v(dout1_3) AT=1840.05n

.meas tran vdout1_4ck1830 FIND v(dout1_4) AT=1840.05n

.meas tran vdout1_5ck1830 FIND v(dout1_5) AT=1840.05n

.meas tran vdout1_6ck1830 FIND v(dout1_6) AT=1840.05n

.meas tran vdout1_7ck1830 FIND v(dout1_7) AT=1840.05n

.meas tran vdout1_8ck1830 FIND v(dout1_8) AT=1840.05n

.meas tran vdout1_9ck1830 FIND v(dout1_9) AT=1840.05n

.meas tran vdout1_10ck1830 FIND v(dout1_10) AT=1840.05n

.meas tran vdout1_11ck1830 FIND v(dout1_11) AT=1840.05n

.meas tran vdout1_12ck1830 FIND v(dout1_12) AT=1840.05n

.meas tran vdout1_13ck1830 FIND v(dout1_13) AT=1840.05n

.meas tran vdout1_14ck1830 FIND v(dout1_14) AT=1840.05n

.meas tran vdout1_15ck1830 FIND v(dout1_15) AT=1840.05n

.meas tran vdout1_16ck1830 FIND v(dout1_16) AT=1840.05n

.meas tran vdout1_17ck1830 FIND v(dout1_17) AT=1840.05n

.meas tran vdout1_18ck1830 FIND v(dout1_18) AT=1840.05n

.meas tran vdout1_0ck1850 FIND v(dout1_0) AT=1860.05n

.meas tran vdout1_1ck1850 FIND v(dout1_1) AT=1860.05n

.meas tran vdout1_2ck1850 FIND v(dout1_2) AT=1860.05n

.meas tran vdout1_3ck1850 FIND v(dout1_3) AT=1860.05n

.meas tran vdout1_4ck1850 FIND v(dout1_4) AT=1860.05n

.meas tran vdout1_5ck1850 FIND v(dout1_5) AT=1860.05n

.meas tran vdout1_6ck1850 FIND v(dout1_6) AT=1860.05n

.meas tran vdout1_7ck1850 FIND v(dout1_7) AT=1860.05n

.meas tran vdout1_8ck1850 FIND v(dout1_8) AT=1860.05n

.meas tran vdout1_9ck1850 FIND v(dout1_9) AT=1860.05n

.meas tran vdout1_10ck1850 FIND v(dout1_10) AT=1860.05n

.meas tran vdout1_11ck1850 FIND v(dout1_11) AT=1860.05n

.meas tran vdout1_12ck1850 FIND v(dout1_12) AT=1860.05n

.meas tran vdout1_13ck1850 FIND v(dout1_13) AT=1860.05n

.meas tran vdout1_14ck1850 FIND v(dout1_14) AT=1860.05n

.meas tran vdout1_15ck1850 FIND v(dout1_15) AT=1860.05n

.meas tran vdout1_16ck1850 FIND v(dout1_16) AT=1860.05n

.meas tran vdout1_17ck1850 FIND v(dout1_17) AT=1860.05n

.meas tran vdout1_18ck1850 FIND v(dout1_18) AT=1860.05n

.meas tran vdout1_0ck1880 FIND v(dout1_0) AT=1890.05n

.meas tran vdout1_1ck1880 FIND v(dout1_1) AT=1890.05n

.meas tran vdout1_2ck1880 FIND v(dout1_2) AT=1890.05n

.meas tran vdout1_3ck1880 FIND v(dout1_3) AT=1890.05n

.meas tran vdout1_4ck1880 FIND v(dout1_4) AT=1890.05n

.meas tran vdout1_5ck1880 FIND v(dout1_5) AT=1890.05n

.meas tran vdout1_6ck1880 FIND v(dout1_6) AT=1890.05n

.meas tran vdout1_7ck1880 FIND v(dout1_7) AT=1890.05n

.meas tran vdout1_8ck1880 FIND v(dout1_8) AT=1890.05n

.meas tran vdout1_9ck1880 FIND v(dout1_9) AT=1890.05n

.meas tran vdout1_10ck1880 FIND v(dout1_10) AT=1890.05n

.meas tran vdout1_11ck1880 FIND v(dout1_11) AT=1890.05n

.meas tran vdout1_12ck1880 FIND v(dout1_12) AT=1890.05n

.meas tran vdout1_13ck1880 FIND v(dout1_13) AT=1890.05n

.meas tran vdout1_14ck1880 FIND v(dout1_14) AT=1890.05n

.meas tran vdout1_15ck1880 FIND v(dout1_15) AT=1890.05n

.meas tran vdout1_16ck1880 FIND v(dout1_16) AT=1890.05n

.meas tran vdout1_17ck1880 FIND v(dout1_17) AT=1890.05n

.meas tran vdout1_18ck1880 FIND v(dout1_18) AT=1890.05n

.meas tran vdout1_0ck1890 FIND v(dout1_0) AT=1900.05n

.meas tran vdout1_1ck1890 FIND v(dout1_1) AT=1900.05n

.meas tran vdout1_2ck1890 FIND v(dout1_2) AT=1900.05n

.meas tran vdout1_3ck1890 FIND v(dout1_3) AT=1900.05n

.meas tran vdout1_4ck1890 FIND v(dout1_4) AT=1900.05n

.meas tran vdout1_5ck1890 FIND v(dout1_5) AT=1900.05n

.meas tran vdout1_6ck1890 FIND v(dout1_6) AT=1900.05n

.meas tran vdout1_7ck1890 FIND v(dout1_7) AT=1900.05n

.meas tran vdout1_8ck1890 FIND v(dout1_8) AT=1900.05n

.meas tran vdout1_9ck1890 FIND v(dout1_9) AT=1900.05n

.meas tran vdout1_10ck1890 FIND v(dout1_10) AT=1900.05n

.meas tran vdout1_11ck1890 FIND v(dout1_11) AT=1900.05n

.meas tran vdout1_12ck1890 FIND v(dout1_12) AT=1900.05n

.meas tran vdout1_13ck1890 FIND v(dout1_13) AT=1900.05n

.meas tran vdout1_14ck1890 FIND v(dout1_14) AT=1900.05n

.meas tran vdout1_15ck1890 FIND v(dout1_15) AT=1900.05n

.meas tran vdout1_16ck1890 FIND v(dout1_16) AT=1900.05n

.meas tran vdout1_17ck1890 FIND v(dout1_17) AT=1900.05n

.meas tran vdout1_18ck1890 FIND v(dout1_18) AT=1900.05n

.meas tran vdout1_0ck1920 FIND v(dout1_0) AT=1930.05n

.meas tran vdout1_1ck1920 FIND v(dout1_1) AT=1930.05n

.meas tran vdout1_2ck1920 FIND v(dout1_2) AT=1930.05n

.meas tran vdout1_3ck1920 FIND v(dout1_3) AT=1930.05n

.meas tran vdout1_4ck1920 FIND v(dout1_4) AT=1930.05n

.meas tran vdout1_5ck1920 FIND v(dout1_5) AT=1930.05n

.meas tran vdout1_6ck1920 FIND v(dout1_6) AT=1930.05n

.meas tran vdout1_7ck1920 FIND v(dout1_7) AT=1930.05n

.meas tran vdout1_8ck1920 FIND v(dout1_8) AT=1930.05n

.meas tran vdout1_9ck1920 FIND v(dout1_9) AT=1930.05n

.meas tran vdout1_10ck1920 FIND v(dout1_10) AT=1930.05n

.meas tran vdout1_11ck1920 FIND v(dout1_11) AT=1930.05n

.meas tran vdout1_12ck1920 FIND v(dout1_12) AT=1930.05n

.meas tran vdout1_13ck1920 FIND v(dout1_13) AT=1930.05n

.meas tran vdout1_14ck1920 FIND v(dout1_14) AT=1930.05n

.meas tran vdout1_15ck1920 FIND v(dout1_15) AT=1930.05n

.meas tran vdout1_16ck1920 FIND v(dout1_16) AT=1930.05n

.meas tran vdout1_17ck1920 FIND v(dout1_17) AT=1930.05n

.meas tran vdout1_18ck1920 FIND v(dout1_18) AT=1930.05n

.meas tran vdout1_0ck1960 FIND v(dout1_0) AT=1970.05n

.meas tran vdout1_1ck1960 FIND v(dout1_1) AT=1970.05n

.meas tran vdout1_2ck1960 FIND v(dout1_2) AT=1970.05n

.meas tran vdout1_3ck1960 FIND v(dout1_3) AT=1970.05n

.meas tran vdout1_4ck1960 FIND v(dout1_4) AT=1970.05n

.meas tran vdout1_5ck1960 FIND v(dout1_5) AT=1970.05n

.meas tran vdout1_6ck1960 FIND v(dout1_6) AT=1970.05n

.meas tran vdout1_7ck1960 FIND v(dout1_7) AT=1970.05n

.meas tran vdout1_8ck1960 FIND v(dout1_8) AT=1970.05n

.meas tran vdout1_9ck1960 FIND v(dout1_9) AT=1970.05n

.meas tran vdout1_10ck1960 FIND v(dout1_10) AT=1970.05n

.meas tran vdout1_11ck1960 FIND v(dout1_11) AT=1970.05n

.meas tran vdout1_12ck1960 FIND v(dout1_12) AT=1970.05n

.meas tran vdout1_13ck1960 FIND v(dout1_13) AT=1970.05n

.meas tran vdout1_14ck1960 FIND v(dout1_14) AT=1970.05n

.meas tran vdout1_15ck1960 FIND v(dout1_15) AT=1970.05n

.meas tran vdout1_16ck1960 FIND v(dout1_16) AT=1970.05n

.meas tran vdout1_17ck1960 FIND v(dout1_17) AT=1970.05n

.meas tran vdout1_18ck1960 FIND v(dout1_18) AT=1970.05n

.meas tran vdout1_0ck1970 FIND v(dout1_0) AT=1980.05n

.meas tran vdout1_1ck1970 FIND v(dout1_1) AT=1980.05n

.meas tran vdout1_2ck1970 FIND v(dout1_2) AT=1980.05n

.meas tran vdout1_3ck1970 FIND v(dout1_3) AT=1980.05n

.meas tran vdout1_4ck1970 FIND v(dout1_4) AT=1980.05n

.meas tran vdout1_5ck1970 FIND v(dout1_5) AT=1980.05n

.meas tran vdout1_6ck1970 FIND v(dout1_6) AT=1980.05n

.meas tran vdout1_7ck1970 FIND v(dout1_7) AT=1980.05n

.meas tran vdout1_8ck1970 FIND v(dout1_8) AT=1980.05n

.meas tran vdout1_9ck1970 FIND v(dout1_9) AT=1980.05n

.meas tran vdout1_10ck1970 FIND v(dout1_10) AT=1980.05n

.meas tran vdout1_11ck1970 FIND v(dout1_11) AT=1980.05n

.meas tran vdout1_12ck1970 FIND v(dout1_12) AT=1980.05n

.meas tran vdout1_13ck1970 FIND v(dout1_13) AT=1980.05n

.meas tran vdout1_14ck1970 FIND v(dout1_14) AT=1980.05n

.meas tran vdout1_15ck1970 FIND v(dout1_15) AT=1980.05n

.meas tran vdout1_16ck1970 FIND v(dout1_16) AT=1980.05n

.meas tran vdout1_17ck1970 FIND v(dout1_17) AT=1980.05n

.meas tran vdout1_18ck1970 FIND v(dout1_18) AT=1980.05n

.meas tran vdout1_0ck2000 FIND v(dout1_0) AT=2010.05n

.meas tran vdout1_1ck2000 FIND v(dout1_1) AT=2010.05n

.meas tran vdout1_2ck2000 FIND v(dout1_2) AT=2010.05n

.meas tran vdout1_3ck2000 FIND v(dout1_3) AT=2010.05n

.meas tran vdout1_4ck2000 FIND v(dout1_4) AT=2010.05n

.meas tran vdout1_5ck2000 FIND v(dout1_5) AT=2010.05n

.meas tran vdout1_6ck2000 FIND v(dout1_6) AT=2010.05n

.meas tran vdout1_7ck2000 FIND v(dout1_7) AT=2010.05n

.meas tran vdout1_8ck2000 FIND v(dout1_8) AT=2010.05n

.meas tran vdout1_9ck2000 FIND v(dout1_9) AT=2010.05n

.meas tran vdout1_10ck2000 FIND v(dout1_10) AT=2010.05n

.meas tran vdout1_11ck2000 FIND v(dout1_11) AT=2010.05n

.meas tran vdout1_12ck2000 FIND v(dout1_12) AT=2010.05n

.meas tran vdout1_13ck2000 FIND v(dout1_13) AT=2010.05n

.meas tran vdout1_14ck2000 FIND v(dout1_14) AT=2010.05n

.meas tran vdout1_15ck2000 FIND v(dout1_15) AT=2010.05n

.meas tran vdout1_16ck2000 FIND v(dout1_16) AT=2010.05n

.meas tran vdout1_17ck2000 FIND v(dout1_17) AT=2010.05n

.meas tran vdout1_18ck2000 FIND v(dout1_18) AT=2010.05n

.meas tran vdout1_0ck2020 FIND v(dout1_0) AT=2030.05n

.meas tran vdout1_1ck2020 FIND v(dout1_1) AT=2030.05n

.meas tran vdout1_2ck2020 FIND v(dout1_2) AT=2030.05n

.meas tran vdout1_3ck2020 FIND v(dout1_3) AT=2030.05n

.meas tran vdout1_4ck2020 FIND v(dout1_4) AT=2030.05n

.meas tran vdout1_5ck2020 FIND v(dout1_5) AT=2030.05n

.meas tran vdout1_6ck2020 FIND v(dout1_6) AT=2030.05n

.meas tran vdout1_7ck2020 FIND v(dout1_7) AT=2030.05n

.meas tran vdout1_8ck2020 FIND v(dout1_8) AT=2030.05n

.meas tran vdout1_9ck2020 FIND v(dout1_9) AT=2030.05n

.meas tran vdout1_10ck2020 FIND v(dout1_10) AT=2030.05n

.meas tran vdout1_11ck2020 FIND v(dout1_11) AT=2030.05n

.meas tran vdout1_12ck2020 FIND v(dout1_12) AT=2030.05n

.meas tran vdout1_13ck2020 FIND v(dout1_13) AT=2030.05n

.meas tran vdout1_14ck2020 FIND v(dout1_14) AT=2030.05n

.meas tran vdout1_15ck2020 FIND v(dout1_15) AT=2030.05n

.meas tran vdout1_16ck2020 FIND v(dout1_16) AT=2030.05n

.meas tran vdout1_17ck2020 FIND v(dout1_17) AT=2030.05n

.meas tran vdout1_18ck2020 FIND v(dout1_18) AT=2030.05n
