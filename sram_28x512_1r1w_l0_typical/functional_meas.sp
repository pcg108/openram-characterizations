.meas tran vdout1_0ck40 FIND v(dout1_0) AT=50.05n

.meas tran vdout1_1ck40 FIND v(dout1_1) AT=50.05n

.meas tran vdout1_2ck40 FIND v(dout1_2) AT=50.05n

.meas tran vdout1_3ck40 FIND v(dout1_3) AT=50.05n

.meas tran vdout1_4ck40 FIND v(dout1_4) AT=50.05n

.meas tran vdout1_5ck40 FIND v(dout1_5) AT=50.05n

.meas tran vdout1_6ck40 FIND v(dout1_6) AT=50.05n

.meas tran vdout1_7ck40 FIND v(dout1_7) AT=50.05n

.meas tran vdout1_8ck40 FIND v(dout1_8) AT=50.05n

.meas tran vdout1_9ck40 FIND v(dout1_9) AT=50.05n

.meas tran vdout1_10ck40 FIND v(dout1_10) AT=50.05n

.meas tran vdout1_11ck40 FIND v(dout1_11) AT=50.05n

.meas tran vdout1_12ck40 FIND v(dout1_12) AT=50.05n

.meas tran vdout1_13ck40 FIND v(dout1_13) AT=50.05n

.meas tran vdout1_14ck40 FIND v(dout1_14) AT=50.05n

.meas tran vdout1_15ck40 FIND v(dout1_15) AT=50.05n

.meas tran vdout1_16ck40 FIND v(dout1_16) AT=50.05n

.meas tran vdout1_17ck40 FIND v(dout1_17) AT=50.05n

.meas tran vdout1_18ck40 FIND v(dout1_18) AT=50.05n

.meas tran vdout1_19ck40 FIND v(dout1_19) AT=50.05n

.meas tran vdout1_20ck40 FIND v(dout1_20) AT=50.05n

.meas tran vdout1_21ck40 FIND v(dout1_21) AT=50.05n

.meas tran vdout1_22ck40 FIND v(dout1_22) AT=50.05n

.meas tran vdout1_23ck40 FIND v(dout1_23) AT=50.05n

.meas tran vdout1_24ck40 FIND v(dout1_24) AT=50.05n

.meas tran vdout1_25ck40 FIND v(dout1_25) AT=50.05n

.meas tran vdout1_26ck40 FIND v(dout1_26) AT=50.05n

.meas tran vdout1_27ck40 FIND v(dout1_27) AT=50.05n

.meas tran vdout1_0ck50 FIND v(dout1_0) AT=60.05n

.meas tran vdout1_1ck50 FIND v(dout1_1) AT=60.05n

.meas tran vdout1_2ck50 FIND v(dout1_2) AT=60.05n

.meas tran vdout1_3ck50 FIND v(dout1_3) AT=60.05n

.meas tran vdout1_4ck50 FIND v(dout1_4) AT=60.05n

.meas tran vdout1_5ck50 FIND v(dout1_5) AT=60.05n

.meas tran vdout1_6ck50 FIND v(dout1_6) AT=60.05n

.meas tran vdout1_7ck50 FIND v(dout1_7) AT=60.05n

.meas tran vdout1_8ck50 FIND v(dout1_8) AT=60.05n

.meas tran vdout1_9ck50 FIND v(dout1_9) AT=60.05n

.meas tran vdout1_10ck50 FIND v(dout1_10) AT=60.05n

.meas tran vdout1_11ck50 FIND v(dout1_11) AT=60.05n

.meas tran vdout1_12ck50 FIND v(dout1_12) AT=60.05n

.meas tran vdout1_13ck50 FIND v(dout1_13) AT=60.05n

.meas tran vdout1_14ck50 FIND v(dout1_14) AT=60.05n

.meas tran vdout1_15ck50 FIND v(dout1_15) AT=60.05n

.meas tran vdout1_16ck50 FIND v(dout1_16) AT=60.05n

.meas tran vdout1_17ck50 FIND v(dout1_17) AT=60.05n

.meas tran vdout1_18ck50 FIND v(dout1_18) AT=60.05n

.meas tran vdout1_19ck50 FIND v(dout1_19) AT=60.05n

.meas tran vdout1_20ck50 FIND v(dout1_20) AT=60.05n

.meas tran vdout1_21ck50 FIND v(dout1_21) AT=60.05n

.meas tran vdout1_22ck50 FIND v(dout1_22) AT=60.05n

.meas tran vdout1_23ck50 FIND v(dout1_23) AT=60.05n

.meas tran vdout1_24ck50 FIND v(dout1_24) AT=60.05n

.meas tran vdout1_25ck50 FIND v(dout1_25) AT=60.05n

.meas tran vdout1_26ck50 FIND v(dout1_26) AT=60.05n

.meas tran vdout1_27ck50 FIND v(dout1_27) AT=60.05n

.meas tran vdout1_0ck100 FIND v(dout1_0) AT=110.05n

.meas tran vdout1_1ck100 FIND v(dout1_1) AT=110.05n

.meas tran vdout1_2ck100 FIND v(dout1_2) AT=110.05n

.meas tran vdout1_3ck100 FIND v(dout1_3) AT=110.05n

.meas tran vdout1_4ck100 FIND v(dout1_4) AT=110.05n

.meas tran vdout1_5ck100 FIND v(dout1_5) AT=110.05n

.meas tran vdout1_6ck100 FIND v(dout1_6) AT=110.05n

.meas tran vdout1_7ck100 FIND v(dout1_7) AT=110.05n

.meas tran vdout1_8ck100 FIND v(dout1_8) AT=110.05n

.meas tran vdout1_9ck100 FIND v(dout1_9) AT=110.05n

.meas tran vdout1_10ck100 FIND v(dout1_10) AT=110.05n

.meas tran vdout1_11ck100 FIND v(dout1_11) AT=110.05n

.meas tran vdout1_12ck100 FIND v(dout1_12) AT=110.05n

.meas tran vdout1_13ck100 FIND v(dout1_13) AT=110.05n

.meas tran vdout1_14ck100 FIND v(dout1_14) AT=110.05n

.meas tran vdout1_15ck100 FIND v(dout1_15) AT=110.05n

.meas tran vdout1_16ck100 FIND v(dout1_16) AT=110.05n

.meas tran vdout1_17ck100 FIND v(dout1_17) AT=110.05n

.meas tran vdout1_18ck100 FIND v(dout1_18) AT=110.05n

.meas tran vdout1_19ck100 FIND v(dout1_19) AT=110.05n

.meas tran vdout1_20ck100 FIND v(dout1_20) AT=110.05n

.meas tran vdout1_21ck100 FIND v(dout1_21) AT=110.05n

.meas tran vdout1_22ck100 FIND v(dout1_22) AT=110.05n

.meas tran vdout1_23ck100 FIND v(dout1_23) AT=110.05n

.meas tran vdout1_24ck100 FIND v(dout1_24) AT=110.05n

.meas tran vdout1_25ck100 FIND v(dout1_25) AT=110.05n

.meas tran vdout1_26ck100 FIND v(dout1_26) AT=110.05n

.meas tran vdout1_27ck100 FIND v(dout1_27) AT=110.05n

.meas tran vdout1_0ck110 FIND v(dout1_0) AT=120.05n

.meas tran vdout1_1ck110 FIND v(dout1_1) AT=120.05n

.meas tran vdout1_2ck110 FIND v(dout1_2) AT=120.05n

.meas tran vdout1_3ck110 FIND v(dout1_3) AT=120.05n

.meas tran vdout1_4ck110 FIND v(dout1_4) AT=120.05n

.meas tran vdout1_5ck110 FIND v(dout1_5) AT=120.05n

.meas tran vdout1_6ck110 FIND v(dout1_6) AT=120.05n

.meas tran vdout1_7ck110 FIND v(dout1_7) AT=120.05n

.meas tran vdout1_8ck110 FIND v(dout1_8) AT=120.05n

.meas tran vdout1_9ck110 FIND v(dout1_9) AT=120.05n

.meas tran vdout1_10ck110 FIND v(dout1_10) AT=120.05n

.meas tran vdout1_11ck110 FIND v(dout1_11) AT=120.05n

.meas tran vdout1_12ck110 FIND v(dout1_12) AT=120.05n

.meas tran vdout1_13ck110 FIND v(dout1_13) AT=120.05n

.meas tran vdout1_14ck110 FIND v(dout1_14) AT=120.05n

.meas tran vdout1_15ck110 FIND v(dout1_15) AT=120.05n

.meas tran vdout1_16ck110 FIND v(dout1_16) AT=120.05n

.meas tran vdout1_17ck110 FIND v(dout1_17) AT=120.05n

.meas tran vdout1_18ck110 FIND v(dout1_18) AT=120.05n

.meas tran vdout1_19ck110 FIND v(dout1_19) AT=120.05n

.meas tran vdout1_20ck110 FIND v(dout1_20) AT=120.05n

.meas tran vdout1_21ck110 FIND v(dout1_21) AT=120.05n

.meas tran vdout1_22ck110 FIND v(dout1_22) AT=120.05n

.meas tran vdout1_23ck110 FIND v(dout1_23) AT=120.05n

.meas tran vdout1_24ck110 FIND v(dout1_24) AT=120.05n

.meas tran vdout1_25ck110 FIND v(dout1_25) AT=120.05n

.meas tran vdout1_26ck110 FIND v(dout1_26) AT=120.05n

.meas tran vdout1_27ck110 FIND v(dout1_27) AT=120.05n

.meas tran vdout1_0ck130 FIND v(dout1_0) AT=140.05n

.meas tran vdout1_1ck130 FIND v(dout1_1) AT=140.05n

.meas tran vdout1_2ck130 FIND v(dout1_2) AT=140.05n

.meas tran vdout1_3ck130 FIND v(dout1_3) AT=140.05n

.meas tran vdout1_4ck130 FIND v(dout1_4) AT=140.05n

.meas tran vdout1_5ck130 FIND v(dout1_5) AT=140.05n

.meas tran vdout1_6ck130 FIND v(dout1_6) AT=140.05n

.meas tran vdout1_7ck130 FIND v(dout1_7) AT=140.05n

.meas tran vdout1_8ck130 FIND v(dout1_8) AT=140.05n

.meas tran vdout1_9ck130 FIND v(dout1_9) AT=140.05n

.meas tran vdout1_10ck130 FIND v(dout1_10) AT=140.05n

.meas tran vdout1_11ck130 FIND v(dout1_11) AT=140.05n

.meas tran vdout1_12ck130 FIND v(dout1_12) AT=140.05n

.meas tran vdout1_13ck130 FIND v(dout1_13) AT=140.05n

.meas tran vdout1_14ck130 FIND v(dout1_14) AT=140.05n

.meas tran vdout1_15ck130 FIND v(dout1_15) AT=140.05n

.meas tran vdout1_16ck130 FIND v(dout1_16) AT=140.05n

.meas tran vdout1_17ck130 FIND v(dout1_17) AT=140.05n

.meas tran vdout1_18ck130 FIND v(dout1_18) AT=140.05n

.meas tran vdout1_19ck130 FIND v(dout1_19) AT=140.05n

.meas tran vdout1_20ck130 FIND v(dout1_20) AT=140.05n

.meas tran vdout1_21ck130 FIND v(dout1_21) AT=140.05n

.meas tran vdout1_22ck130 FIND v(dout1_22) AT=140.05n

.meas tran vdout1_23ck130 FIND v(dout1_23) AT=140.05n

.meas tran vdout1_24ck130 FIND v(dout1_24) AT=140.05n

.meas tran vdout1_25ck130 FIND v(dout1_25) AT=140.05n

.meas tran vdout1_26ck130 FIND v(dout1_26) AT=140.05n

.meas tran vdout1_27ck130 FIND v(dout1_27) AT=140.05n

.meas tran vdout1_0ck180 FIND v(dout1_0) AT=190.05n

.meas tran vdout1_1ck180 FIND v(dout1_1) AT=190.05n

.meas tran vdout1_2ck180 FIND v(dout1_2) AT=190.05n

.meas tran vdout1_3ck180 FIND v(dout1_3) AT=190.05n

.meas tran vdout1_4ck180 FIND v(dout1_4) AT=190.05n

.meas tran vdout1_5ck180 FIND v(dout1_5) AT=190.05n

.meas tran vdout1_6ck180 FIND v(dout1_6) AT=190.05n

.meas tran vdout1_7ck180 FIND v(dout1_7) AT=190.05n

.meas tran vdout1_8ck180 FIND v(dout1_8) AT=190.05n

.meas tran vdout1_9ck180 FIND v(dout1_9) AT=190.05n

.meas tran vdout1_10ck180 FIND v(dout1_10) AT=190.05n

.meas tran vdout1_11ck180 FIND v(dout1_11) AT=190.05n

.meas tran vdout1_12ck180 FIND v(dout1_12) AT=190.05n

.meas tran vdout1_13ck180 FIND v(dout1_13) AT=190.05n

.meas tran vdout1_14ck180 FIND v(dout1_14) AT=190.05n

.meas tran vdout1_15ck180 FIND v(dout1_15) AT=190.05n

.meas tran vdout1_16ck180 FIND v(dout1_16) AT=190.05n

.meas tran vdout1_17ck180 FIND v(dout1_17) AT=190.05n

.meas tran vdout1_18ck180 FIND v(dout1_18) AT=190.05n

.meas tran vdout1_19ck180 FIND v(dout1_19) AT=190.05n

.meas tran vdout1_20ck180 FIND v(dout1_20) AT=190.05n

.meas tran vdout1_21ck180 FIND v(dout1_21) AT=190.05n

.meas tran vdout1_22ck180 FIND v(dout1_22) AT=190.05n

.meas tran vdout1_23ck180 FIND v(dout1_23) AT=190.05n

.meas tran vdout1_24ck180 FIND v(dout1_24) AT=190.05n

.meas tran vdout1_25ck180 FIND v(dout1_25) AT=190.05n

.meas tran vdout1_26ck180 FIND v(dout1_26) AT=190.05n

.meas tran vdout1_27ck180 FIND v(dout1_27) AT=190.05n

.meas tran vdout1_0ck220 FIND v(dout1_0) AT=230.05n

.meas tran vdout1_1ck220 FIND v(dout1_1) AT=230.05n

.meas tran vdout1_2ck220 FIND v(dout1_2) AT=230.05n

.meas tran vdout1_3ck220 FIND v(dout1_3) AT=230.05n

.meas tran vdout1_4ck220 FIND v(dout1_4) AT=230.05n

.meas tran vdout1_5ck220 FIND v(dout1_5) AT=230.05n

.meas tran vdout1_6ck220 FIND v(dout1_6) AT=230.05n

.meas tran vdout1_7ck220 FIND v(dout1_7) AT=230.05n

.meas tran vdout1_8ck220 FIND v(dout1_8) AT=230.05n

.meas tran vdout1_9ck220 FIND v(dout1_9) AT=230.05n

.meas tran vdout1_10ck220 FIND v(dout1_10) AT=230.05n

.meas tran vdout1_11ck220 FIND v(dout1_11) AT=230.05n

.meas tran vdout1_12ck220 FIND v(dout1_12) AT=230.05n

.meas tran vdout1_13ck220 FIND v(dout1_13) AT=230.05n

.meas tran vdout1_14ck220 FIND v(dout1_14) AT=230.05n

.meas tran vdout1_15ck220 FIND v(dout1_15) AT=230.05n

.meas tran vdout1_16ck220 FIND v(dout1_16) AT=230.05n

.meas tran vdout1_17ck220 FIND v(dout1_17) AT=230.05n

.meas tran vdout1_18ck220 FIND v(dout1_18) AT=230.05n

.meas tran vdout1_19ck220 FIND v(dout1_19) AT=230.05n

.meas tran vdout1_20ck220 FIND v(dout1_20) AT=230.05n

.meas tran vdout1_21ck220 FIND v(dout1_21) AT=230.05n

.meas tran vdout1_22ck220 FIND v(dout1_22) AT=230.05n

.meas tran vdout1_23ck220 FIND v(dout1_23) AT=230.05n

.meas tran vdout1_24ck220 FIND v(dout1_24) AT=230.05n

.meas tran vdout1_25ck220 FIND v(dout1_25) AT=230.05n

.meas tran vdout1_26ck220 FIND v(dout1_26) AT=230.05n

.meas tran vdout1_27ck220 FIND v(dout1_27) AT=230.05n

.meas tran vdout1_0ck240 FIND v(dout1_0) AT=250.05n

.meas tran vdout1_1ck240 FIND v(dout1_1) AT=250.05n

.meas tran vdout1_2ck240 FIND v(dout1_2) AT=250.05n

.meas tran vdout1_3ck240 FIND v(dout1_3) AT=250.05n

.meas tran vdout1_4ck240 FIND v(dout1_4) AT=250.05n

.meas tran vdout1_5ck240 FIND v(dout1_5) AT=250.05n

.meas tran vdout1_6ck240 FIND v(dout1_6) AT=250.05n

.meas tran vdout1_7ck240 FIND v(dout1_7) AT=250.05n

.meas tran vdout1_8ck240 FIND v(dout1_8) AT=250.05n

.meas tran vdout1_9ck240 FIND v(dout1_9) AT=250.05n

.meas tran vdout1_10ck240 FIND v(dout1_10) AT=250.05n

.meas tran vdout1_11ck240 FIND v(dout1_11) AT=250.05n

.meas tran vdout1_12ck240 FIND v(dout1_12) AT=250.05n

.meas tran vdout1_13ck240 FIND v(dout1_13) AT=250.05n

.meas tran vdout1_14ck240 FIND v(dout1_14) AT=250.05n

.meas tran vdout1_15ck240 FIND v(dout1_15) AT=250.05n

.meas tran vdout1_16ck240 FIND v(dout1_16) AT=250.05n

.meas tran vdout1_17ck240 FIND v(dout1_17) AT=250.05n

.meas tran vdout1_18ck240 FIND v(dout1_18) AT=250.05n

.meas tran vdout1_19ck240 FIND v(dout1_19) AT=250.05n

.meas tran vdout1_20ck240 FIND v(dout1_20) AT=250.05n

.meas tran vdout1_21ck240 FIND v(dout1_21) AT=250.05n

.meas tran vdout1_22ck240 FIND v(dout1_22) AT=250.05n

.meas tran vdout1_23ck240 FIND v(dout1_23) AT=250.05n

.meas tran vdout1_24ck240 FIND v(dout1_24) AT=250.05n

.meas tran vdout1_25ck240 FIND v(dout1_25) AT=250.05n

.meas tran vdout1_26ck240 FIND v(dout1_26) AT=250.05n

.meas tran vdout1_27ck240 FIND v(dout1_27) AT=250.05n

.meas tran vdout1_0ck270 FIND v(dout1_0) AT=280.05n

.meas tran vdout1_1ck270 FIND v(dout1_1) AT=280.05n

.meas tran vdout1_2ck270 FIND v(dout1_2) AT=280.05n

.meas tran vdout1_3ck270 FIND v(dout1_3) AT=280.05n

.meas tran vdout1_4ck270 FIND v(dout1_4) AT=280.05n

.meas tran vdout1_5ck270 FIND v(dout1_5) AT=280.05n

.meas tran vdout1_6ck270 FIND v(dout1_6) AT=280.05n

.meas tran vdout1_7ck270 FIND v(dout1_7) AT=280.05n

.meas tran vdout1_8ck270 FIND v(dout1_8) AT=280.05n

.meas tran vdout1_9ck270 FIND v(dout1_9) AT=280.05n

.meas tran vdout1_10ck270 FIND v(dout1_10) AT=280.05n

.meas tran vdout1_11ck270 FIND v(dout1_11) AT=280.05n

.meas tran vdout1_12ck270 FIND v(dout1_12) AT=280.05n

.meas tran vdout1_13ck270 FIND v(dout1_13) AT=280.05n

.meas tran vdout1_14ck270 FIND v(dout1_14) AT=280.05n

.meas tran vdout1_15ck270 FIND v(dout1_15) AT=280.05n

.meas tran vdout1_16ck270 FIND v(dout1_16) AT=280.05n

.meas tran vdout1_17ck270 FIND v(dout1_17) AT=280.05n

.meas tran vdout1_18ck270 FIND v(dout1_18) AT=280.05n

.meas tran vdout1_19ck270 FIND v(dout1_19) AT=280.05n

.meas tran vdout1_20ck270 FIND v(dout1_20) AT=280.05n

.meas tran vdout1_21ck270 FIND v(dout1_21) AT=280.05n

.meas tran vdout1_22ck270 FIND v(dout1_22) AT=280.05n

.meas tran vdout1_23ck270 FIND v(dout1_23) AT=280.05n

.meas tran vdout1_24ck270 FIND v(dout1_24) AT=280.05n

.meas tran vdout1_25ck270 FIND v(dout1_25) AT=280.05n

.meas tran vdout1_26ck270 FIND v(dout1_26) AT=280.05n

.meas tran vdout1_27ck270 FIND v(dout1_27) AT=280.05n

.meas tran vdout1_0ck310 FIND v(dout1_0) AT=320.05n

.meas tran vdout1_1ck310 FIND v(dout1_1) AT=320.05n

.meas tran vdout1_2ck310 FIND v(dout1_2) AT=320.05n

.meas tran vdout1_3ck310 FIND v(dout1_3) AT=320.05n

.meas tran vdout1_4ck310 FIND v(dout1_4) AT=320.05n

.meas tran vdout1_5ck310 FIND v(dout1_5) AT=320.05n

.meas tran vdout1_6ck310 FIND v(dout1_6) AT=320.05n

.meas tran vdout1_7ck310 FIND v(dout1_7) AT=320.05n

.meas tran vdout1_8ck310 FIND v(dout1_8) AT=320.05n

.meas tran vdout1_9ck310 FIND v(dout1_9) AT=320.05n

.meas tran vdout1_10ck310 FIND v(dout1_10) AT=320.05n

.meas tran vdout1_11ck310 FIND v(dout1_11) AT=320.05n

.meas tran vdout1_12ck310 FIND v(dout1_12) AT=320.05n

.meas tran vdout1_13ck310 FIND v(dout1_13) AT=320.05n

.meas tran vdout1_14ck310 FIND v(dout1_14) AT=320.05n

.meas tran vdout1_15ck310 FIND v(dout1_15) AT=320.05n

.meas tran vdout1_16ck310 FIND v(dout1_16) AT=320.05n

.meas tran vdout1_17ck310 FIND v(dout1_17) AT=320.05n

.meas tran vdout1_18ck310 FIND v(dout1_18) AT=320.05n

.meas tran vdout1_19ck310 FIND v(dout1_19) AT=320.05n

.meas tran vdout1_20ck310 FIND v(dout1_20) AT=320.05n

.meas tran vdout1_21ck310 FIND v(dout1_21) AT=320.05n

.meas tran vdout1_22ck310 FIND v(dout1_22) AT=320.05n

.meas tran vdout1_23ck310 FIND v(dout1_23) AT=320.05n

.meas tran vdout1_24ck310 FIND v(dout1_24) AT=320.05n

.meas tran vdout1_25ck310 FIND v(dout1_25) AT=320.05n

.meas tran vdout1_26ck310 FIND v(dout1_26) AT=320.05n

.meas tran vdout1_27ck310 FIND v(dout1_27) AT=320.05n

.meas tran vdout1_0ck340 FIND v(dout1_0) AT=350.05n

.meas tran vdout1_1ck340 FIND v(dout1_1) AT=350.05n

.meas tran vdout1_2ck340 FIND v(dout1_2) AT=350.05n

.meas tran vdout1_3ck340 FIND v(dout1_3) AT=350.05n

.meas tran vdout1_4ck340 FIND v(dout1_4) AT=350.05n

.meas tran vdout1_5ck340 FIND v(dout1_5) AT=350.05n

.meas tran vdout1_6ck340 FIND v(dout1_6) AT=350.05n

.meas tran vdout1_7ck340 FIND v(dout1_7) AT=350.05n

.meas tran vdout1_8ck340 FIND v(dout1_8) AT=350.05n

.meas tran vdout1_9ck340 FIND v(dout1_9) AT=350.05n

.meas tran vdout1_10ck340 FIND v(dout1_10) AT=350.05n

.meas tran vdout1_11ck340 FIND v(dout1_11) AT=350.05n

.meas tran vdout1_12ck340 FIND v(dout1_12) AT=350.05n

.meas tran vdout1_13ck340 FIND v(dout1_13) AT=350.05n

.meas tran vdout1_14ck340 FIND v(dout1_14) AT=350.05n

.meas tran vdout1_15ck340 FIND v(dout1_15) AT=350.05n

.meas tran vdout1_16ck340 FIND v(dout1_16) AT=350.05n

.meas tran vdout1_17ck340 FIND v(dout1_17) AT=350.05n

.meas tran vdout1_18ck340 FIND v(dout1_18) AT=350.05n

.meas tran vdout1_19ck340 FIND v(dout1_19) AT=350.05n

.meas tran vdout1_20ck340 FIND v(dout1_20) AT=350.05n

.meas tran vdout1_21ck340 FIND v(dout1_21) AT=350.05n

.meas tran vdout1_22ck340 FIND v(dout1_22) AT=350.05n

.meas tran vdout1_23ck340 FIND v(dout1_23) AT=350.05n

.meas tran vdout1_24ck340 FIND v(dout1_24) AT=350.05n

.meas tran vdout1_25ck340 FIND v(dout1_25) AT=350.05n

.meas tran vdout1_26ck340 FIND v(dout1_26) AT=350.05n

.meas tran vdout1_27ck340 FIND v(dout1_27) AT=350.05n

.meas tran vdout1_0ck360 FIND v(dout1_0) AT=370.05n

.meas tran vdout1_1ck360 FIND v(dout1_1) AT=370.05n

.meas tran vdout1_2ck360 FIND v(dout1_2) AT=370.05n

.meas tran vdout1_3ck360 FIND v(dout1_3) AT=370.05n

.meas tran vdout1_4ck360 FIND v(dout1_4) AT=370.05n

.meas tran vdout1_5ck360 FIND v(dout1_5) AT=370.05n

.meas tran vdout1_6ck360 FIND v(dout1_6) AT=370.05n

.meas tran vdout1_7ck360 FIND v(dout1_7) AT=370.05n

.meas tran vdout1_8ck360 FIND v(dout1_8) AT=370.05n

.meas tran vdout1_9ck360 FIND v(dout1_9) AT=370.05n

.meas tran vdout1_10ck360 FIND v(dout1_10) AT=370.05n

.meas tran vdout1_11ck360 FIND v(dout1_11) AT=370.05n

.meas tran vdout1_12ck360 FIND v(dout1_12) AT=370.05n

.meas tran vdout1_13ck360 FIND v(dout1_13) AT=370.05n

.meas tran vdout1_14ck360 FIND v(dout1_14) AT=370.05n

.meas tran vdout1_15ck360 FIND v(dout1_15) AT=370.05n

.meas tran vdout1_16ck360 FIND v(dout1_16) AT=370.05n

.meas tran vdout1_17ck360 FIND v(dout1_17) AT=370.05n

.meas tran vdout1_18ck360 FIND v(dout1_18) AT=370.05n

.meas tran vdout1_19ck360 FIND v(dout1_19) AT=370.05n

.meas tran vdout1_20ck360 FIND v(dout1_20) AT=370.05n

.meas tran vdout1_21ck360 FIND v(dout1_21) AT=370.05n

.meas tran vdout1_22ck360 FIND v(dout1_22) AT=370.05n

.meas tran vdout1_23ck360 FIND v(dout1_23) AT=370.05n

.meas tran vdout1_24ck360 FIND v(dout1_24) AT=370.05n

.meas tran vdout1_25ck360 FIND v(dout1_25) AT=370.05n

.meas tran vdout1_26ck360 FIND v(dout1_26) AT=370.05n

.meas tran vdout1_27ck360 FIND v(dout1_27) AT=370.05n

.meas tran vdout1_0ck370 FIND v(dout1_0) AT=380.05n

.meas tran vdout1_1ck370 FIND v(dout1_1) AT=380.05n

.meas tran vdout1_2ck370 FIND v(dout1_2) AT=380.05n

.meas tran vdout1_3ck370 FIND v(dout1_3) AT=380.05n

.meas tran vdout1_4ck370 FIND v(dout1_4) AT=380.05n

.meas tran vdout1_5ck370 FIND v(dout1_5) AT=380.05n

.meas tran vdout1_6ck370 FIND v(dout1_6) AT=380.05n

.meas tran vdout1_7ck370 FIND v(dout1_7) AT=380.05n

.meas tran vdout1_8ck370 FIND v(dout1_8) AT=380.05n

.meas tran vdout1_9ck370 FIND v(dout1_9) AT=380.05n

.meas tran vdout1_10ck370 FIND v(dout1_10) AT=380.05n

.meas tran vdout1_11ck370 FIND v(dout1_11) AT=380.05n

.meas tran vdout1_12ck370 FIND v(dout1_12) AT=380.05n

.meas tran vdout1_13ck370 FIND v(dout1_13) AT=380.05n

.meas tran vdout1_14ck370 FIND v(dout1_14) AT=380.05n

.meas tran vdout1_15ck370 FIND v(dout1_15) AT=380.05n

.meas tran vdout1_16ck370 FIND v(dout1_16) AT=380.05n

.meas tran vdout1_17ck370 FIND v(dout1_17) AT=380.05n

.meas tran vdout1_18ck370 FIND v(dout1_18) AT=380.05n

.meas tran vdout1_19ck370 FIND v(dout1_19) AT=380.05n

.meas tran vdout1_20ck370 FIND v(dout1_20) AT=380.05n

.meas tran vdout1_21ck370 FIND v(dout1_21) AT=380.05n

.meas tran vdout1_22ck370 FIND v(dout1_22) AT=380.05n

.meas tran vdout1_23ck370 FIND v(dout1_23) AT=380.05n

.meas tran vdout1_24ck370 FIND v(dout1_24) AT=380.05n

.meas tran vdout1_25ck370 FIND v(dout1_25) AT=380.05n

.meas tran vdout1_26ck370 FIND v(dout1_26) AT=380.05n

.meas tran vdout1_27ck370 FIND v(dout1_27) AT=380.05n

.meas tran vdout1_0ck380 FIND v(dout1_0) AT=390.05n

.meas tran vdout1_1ck380 FIND v(dout1_1) AT=390.05n

.meas tran vdout1_2ck380 FIND v(dout1_2) AT=390.05n

.meas tran vdout1_3ck380 FIND v(dout1_3) AT=390.05n

.meas tran vdout1_4ck380 FIND v(dout1_4) AT=390.05n

.meas tran vdout1_5ck380 FIND v(dout1_5) AT=390.05n

.meas tran vdout1_6ck380 FIND v(dout1_6) AT=390.05n

.meas tran vdout1_7ck380 FIND v(dout1_7) AT=390.05n

.meas tran vdout1_8ck380 FIND v(dout1_8) AT=390.05n

.meas tran vdout1_9ck380 FIND v(dout1_9) AT=390.05n

.meas tran vdout1_10ck380 FIND v(dout1_10) AT=390.05n

.meas tran vdout1_11ck380 FIND v(dout1_11) AT=390.05n

.meas tran vdout1_12ck380 FIND v(dout1_12) AT=390.05n

.meas tran vdout1_13ck380 FIND v(dout1_13) AT=390.05n

.meas tran vdout1_14ck380 FIND v(dout1_14) AT=390.05n

.meas tran vdout1_15ck380 FIND v(dout1_15) AT=390.05n

.meas tran vdout1_16ck380 FIND v(dout1_16) AT=390.05n

.meas tran vdout1_17ck380 FIND v(dout1_17) AT=390.05n

.meas tran vdout1_18ck380 FIND v(dout1_18) AT=390.05n

.meas tran vdout1_19ck380 FIND v(dout1_19) AT=390.05n

.meas tran vdout1_20ck380 FIND v(dout1_20) AT=390.05n

.meas tran vdout1_21ck380 FIND v(dout1_21) AT=390.05n

.meas tran vdout1_22ck380 FIND v(dout1_22) AT=390.05n

.meas tran vdout1_23ck380 FIND v(dout1_23) AT=390.05n

.meas tran vdout1_24ck380 FIND v(dout1_24) AT=390.05n

.meas tran vdout1_25ck380 FIND v(dout1_25) AT=390.05n

.meas tran vdout1_26ck380 FIND v(dout1_26) AT=390.05n

.meas tran vdout1_27ck380 FIND v(dout1_27) AT=390.05n

.meas tran vdout1_0ck440 FIND v(dout1_0) AT=450.05n

.meas tran vdout1_1ck440 FIND v(dout1_1) AT=450.05n

.meas tran vdout1_2ck440 FIND v(dout1_2) AT=450.05n

.meas tran vdout1_3ck440 FIND v(dout1_3) AT=450.05n

.meas tran vdout1_4ck440 FIND v(dout1_4) AT=450.05n

.meas tran vdout1_5ck440 FIND v(dout1_5) AT=450.05n

.meas tran vdout1_6ck440 FIND v(dout1_6) AT=450.05n

.meas tran vdout1_7ck440 FIND v(dout1_7) AT=450.05n

.meas tran vdout1_8ck440 FIND v(dout1_8) AT=450.05n

.meas tran vdout1_9ck440 FIND v(dout1_9) AT=450.05n

.meas tran vdout1_10ck440 FIND v(dout1_10) AT=450.05n

.meas tran vdout1_11ck440 FIND v(dout1_11) AT=450.05n

.meas tran vdout1_12ck440 FIND v(dout1_12) AT=450.05n

.meas tran vdout1_13ck440 FIND v(dout1_13) AT=450.05n

.meas tran vdout1_14ck440 FIND v(dout1_14) AT=450.05n

.meas tran vdout1_15ck440 FIND v(dout1_15) AT=450.05n

.meas tran vdout1_16ck440 FIND v(dout1_16) AT=450.05n

.meas tran vdout1_17ck440 FIND v(dout1_17) AT=450.05n

.meas tran vdout1_18ck440 FIND v(dout1_18) AT=450.05n

.meas tran vdout1_19ck440 FIND v(dout1_19) AT=450.05n

.meas tran vdout1_20ck440 FIND v(dout1_20) AT=450.05n

.meas tran vdout1_21ck440 FIND v(dout1_21) AT=450.05n

.meas tran vdout1_22ck440 FIND v(dout1_22) AT=450.05n

.meas tran vdout1_23ck440 FIND v(dout1_23) AT=450.05n

.meas tran vdout1_24ck440 FIND v(dout1_24) AT=450.05n

.meas tran vdout1_25ck440 FIND v(dout1_25) AT=450.05n

.meas tran vdout1_26ck440 FIND v(dout1_26) AT=450.05n

.meas tran vdout1_27ck440 FIND v(dout1_27) AT=450.05n

.meas tran vdout1_0ck490 FIND v(dout1_0) AT=500.05n

.meas tran vdout1_1ck490 FIND v(dout1_1) AT=500.05n

.meas tran vdout1_2ck490 FIND v(dout1_2) AT=500.05n

.meas tran vdout1_3ck490 FIND v(dout1_3) AT=500.05n

.meas tran vdout1_4ck490 FIND v(dout1_4) AT=500.05n

.meas tran vdout1_5ck490 FIND v(dout1_5) AT=500.05n

.meas tran vdout1_6ck490 FIND v(dout1_6) AT=500.05n

.meas tran vdout1_7ck490 FIND v(dout1_7) AT=500.05n

.meas tran vdout1_8ck490 FIND v(dout1_8) AT=500.05n

.meas tran vdout1_9ck490 FIND v(dout1_9) AT=500.05n

.meas tran vdout1_10ck490 FIND v(dout1_10) AT=500.05n

.meas tran vdout1_11ck490 FIND v(dout1_11) AT=500.05n

.meas tran vdout1_12ck490 FIND v(dout1_12) AT=500.05n

.meas tran vdout1_13ck490 FIND v(dout1_13) AT=500.05n

.meas tran vdout1_14ck490 FIND v(dout1_14) AT=500.05n

.meas tran vdout1_15ck490 FIND v(dout1_15) AT=500.05n

.meas tran vdout1_16ck490 FIND v(dout1_16) AT=500.05n

.meas tran vdout1_17ck490 FIND v(dout1_17) AT=500.05n

.meas tran vdout1_18ck490 FIND v(dout1_18) AT=500.05n

.meas tran vdout1_19ck490 FIND v(dout1_19) AT=500.05n

.meas tran vdout1_20ck490 FIND v(dout1_20) AT=500.05n

.meas tran vdout1_21ck490 FIND v(dout1_21) AT=500.05n

.meas tran vdout1_22ck490 FIND v(dout1_22) AT=500.05n

.meas tran vdout1_23ck490 FIND v(dout1_23) AT=500.05n

.meas tran vdout1_24ck490 FIND v(dout1_24) AT=500.05n

.meas tran vdout1_25ck490 FIND v(dout1_25) AT=500.05n

.meas tran vdout1_26ck490 FIND v(dout1_26) AT=500.05n

.meas tran vdout1_27ck490 FIND v(dout1_27) AT=500.05n

.meas tran vdout1_0ck500 FIND v(dout1_0) AT=510.05n

.meas tran vdout1_1ck500 FIND v(dout1_1) AT=510.05n

.meas tran vdout1_2ck500 FIND v(dout1_2) AT=510.05n

.meas tran vdout1_3ck500 FIND v(dout1_3) AT=510.05n

.meas tran vdout1_4ck500 FIND v(dout1_4) AT=510.05n

.meas tran vdout1_5ck500 FIND v(dout1_5) AT=510.05n

.meas tran vdout1_6ck500 FIND v(dout1_6) AT=510.05n

.meas tran vdout1_7ck500 FIND v(dout1_7) AT=510.05n

.meas tran vdout1_8ck500 FIND v(dout1_8) AT=510.05n

.meas tran vdout1_9ck500 FIND v(dout1_9) AT=510.05n

.meas tran vdout1_10ck500 FIND v(dout1_10) AT=510.05n

.meas tran vdout1_11ck500 FIND v(dout1_11) AT=510.05n

.meas tran vdout1_12ck500 FIND v(dout1_12) AT=510.05n

.meas tran vdout1_13ck500 FIND v(dout1_13) AT=510.05n

.meas tran vdout1_14ck500 FIND v(dout1_14) AT=510.05n

.meas tran vdout1_15ck500 FIND v(dout1_15) AT=510.05n

.meas tran vdout1_16ck500 FIND v(dout1_16) AT=510.05n

.meas tran vdout1_17ck500 FIND v(dout1_17) AT=510.05n

.meas tran vdout1_18ck500 FIND v(dout1_18) AT=510.05n

.meas tran vdout1_19ck500 FIND v(dout1_19) AT=510.05n

.meas tran vdout1_20ck500 FIND v(dout1_20) AT=510.05n

.meas tran vdout1_21ck500 FIND v(dout1_21) AT=510.05n

.meas tran vdout1_22ck500 FIND v(dout1_22) AT=510.05n

.meas tran vdout1_23ck500 FIND v(dout1_23) AT=510.05n

.meas tran vdout1_24ck500 FIND v(dout1_24) AT=510.05n

.meas tran vdout1_25ck500 FIND v(dout1_25) AT=510.05n

.meas tran vdout1_26ck500 FIND v(dout1_26) AT=510.05n

.meas tran vdout1_27ck500 FIND v(dout1_27) AT=510.05n

.meas tran vdout1_0ck520 FIND v(dout1_0) AT=530.05n

.meas tran vdout1_1ck520 FIND v(dout1_1) AT=530.05n

.meas tran vdout1_2ck520 FIND v(dout1_2) AT=530.05n

.meas tran vdout1_3ck520 FIND v(dout1_3) AT=530.05n

.meas tran vdout1_4ck520 FIND v(dout1_4) AT=530.05n

.meas tran vdout1_5ck520 FIND v(dout1_5) AT=530.05n

.meas tran vdout1_6ck520 FIND v(dout1_6) AT=530.05n

.meas tran vdout1_7ck520 FIND v(dout1_7) AT=530.05n

.meas tran vdout1_8ck520 FIND v(dout1_8) AT=530.05n

.meas tran vdout1_9ck520 FIND v(dout1_9) AT=530.05n

.meas tran vdout1_10ck520 FIND v(dout1_10) AT=530.05n

.meas tran vdout1_11ck520 FIND v(dout1_11) AT=530.05n

.meas tran vdout1_12ck520 FIND v(dout1_12) AT=530.05n

.meas tran vdout1_13ck520 FIND v(dout1_13) AT=530.05n

.meas tran vdout1_14ck520 FIND v(dout1_14) AT=530.05n

.meas tran vdout1_15ck520 FIND v(dout1_15) AT=530.05n

.meas tran vdout1_16ck520 FIND v(dout1_16) AT=530.05n

.meas tran vdout1_17ck520 FIND v(dout1_17) AT=530.05n

.meas tran vdout1_18ck520 FIND v(dout1_18) AT=530.05n

.meas tran vdout1_19ck520 FIND v(dout1_19) AT=530.05n

.meas tran vdout1_20ck520 FIND v(dout1_20) AT=530.05n

.meas tran vdout1_21ck520 FIND v(dout1_21) AT=530.05n

.meas tran vdout1_22ck520 FIND v(dout1_22) AT=530.05n

.meas tran vdout1_23ck520 FIND v(dout1_23) AT=530.05n

.meas tran vdout1_24ck520 FIND v(dout1_24) AT=530.05n

.meas tran vdout1_25ck520 FIND v(dout1_25) AT=530.05n

.meas tran vdout1_26ck520 FIND v(dout1_26) AT=530.05n

.meas tran vdout1_27ck520 FIND v(dout1_27) AT=530.05n

.meas tran vdout1_0ck630 FIND v(dout1_0) AT=640.05n

.meas tran vdout1_1ck630 FIND v(dout1_1) AT=640.05n

.meas tran vdout1_2ck630 FIND v(dout1_2) AT=640.05n

.meas tran vdout1_3ck630 FIND v(dout1_3) AT=640.05n

.meas tran vdout1_4ck630 FIND v(dout1_4) AT=640.05n

.meas tran vdout1_5ck630 FIND v(dout1_5) AT=640.05n

.meas tran vdout1_6ck630 FIND v(dout1_6) AT=640.05n

.meas tran vdout1_7ck630 FIND v(dout1_7) AT=640.05n

.meas tran vdout1_8ck630 FIND v(dout1_8) AT=640.05n

.meas tran vdout1_9ck630 FIND v(dout1_9) AT=640.05n

.meas tran vdout1_10ck630 FIND v(dout1_10) AT=640.05n

.meas tran vdout1_11ck630 FIND v(dout1_11) AT=640.05n

.meas tran vdout1_12ck630 FIND v(dout1_12) AT=640.05n

.meas tran vdout1_13ck630 FIND v(dout1_13) AT=640.05n

.meas tran vdout1_14ck630 FIND v(dout1_14) AT=640.05n

.meas tran vdout1_15ck630 FIND v(dout1_15) AT=640.05n

.meas tran vdout1_16ck630 FIND v(dout1_16) AT=640.05n

.meas tran vdout1_17ck630 FIND v(dout1_17) AT=640.05n

.meas tran vdout1_18ck630 FIND v(dout1_18) AT=640.05n

.meas tran vdout1_19ck630 FIND v(dout1_19) AT=640.05n

.meas tran vdout1_20ck630 FIND v(dout1_20) AT=640.05n

.meas tran vdout1_21ck630 FIND v(dout1_21) AT=640.05n

.meas tran vdout1_22ck630 FIND v(dout1_22) AT=640.05n

.meas tran vdout1_23ck630 FIND v(dout1_23) AT=640.05n

.meas tran vdout1_24ck630 FIND v(dout1_24) AT=640.05n

.meas tran vdout1_25ck630 FIND v(dout1_25) AT=640.05n

.meas tran vdout1_26ck630 FIND v(dout1_26) AT=640.05n

.meas tran vdout1_27ck630 FIND v(dout1_27) AT=640.05n

.meas tran vdout1_0ck640 FIND v(dout1_0) AT=650.05n

.meas tran vdout1_1ck640 FIND v(dout1_1) AT=650.05n

.meas tran vdout1_2ck640 FIND v(dout1_2) AT=650.05n

.meas tran vdout1_3ck640 FIND v(dout1_3) AT=650.05n

.meas tran vdout1_4ck640 FIND v(dout1_4) AT=650.05n

.meas tran vdout1_5ck640 FIND v(dout1_5) AT=650.05n

.meas tran vdout1_6ck640 FIND v(dout1_6) AT=650.05n

.meas tran vdout1_7ck640 FIND v(dout1_7) AT=650.05n

.meas tran vdout1_8ck640 FIND v(dout1_8) AT=650.05n

.meas tran vdout1_9ck640 FIND v(dout1_9) AT=650.05n

.meas tran vdout1_10ck640 FIND v(dout1_10) AT=650.05n

.meas tran vdout1_11ck640 FIND v(dout1_11) AT=650.05n

.meas tran vdout1_12ck640 FIND v(dout1_12) AT=650.05n

.meas tran vdout1_13ck640 FIND v(dout1_13) AT=650.05n

.meas tran vdout1_14ck640 FIND v(dout1_14) AT=650.05n

.meas tran vdout1_15ck640 FIND v(dout1_15) AT=650.05n

.meas tran vdout1_16ck640 FIND v(dout1_16) AT=650.05n

.meas tran vdout1_17ck640 FIND v(dout1_17) AT=650.05n

.meas tran vdout1_18ck640 FIND v(dout1_18) AT=650.05n

.meas tran vdout1_19ck640 FIND v(dout1_19) AT=650.05n

.meas tran vdout1_20ck640 FIND v(dout1_20) AT=650.05n

.meas tran vdout1_21ck640 FIND v(dout1_21) AT=650.05n

.meas tran vdout1_22ck640 FIND v(dout1_22) AT=650.05n

.meas tran vdout1_23ck640 FIND v(dout1_23) AT=650.05n

.meas tran vdout1_24ck640 FIND v(dout1_24) AT=650.05n

.meas tran vdout1_25ck640 FIND v(dout1_25) AT=650.05n

.meas tran vdout1_26ck640 FIND v(dout1_26) AT=650.05n

.meas tran vdout1_27ck640 FIND v(dout1_27) AT=650.05n

.meas tran vdout1_0ck670 FIND v(dout1_0) AT=680.05n

.meas tran vdout1_1ck670 FIND v(dout1_1) AT=680.05n

.meas tran vdout1_2ck670 FIND v(dout1_2) AT=680.05n

.meas tran vdout1_3ck670 FIND v(dout1_3) AT=680.05n

.meas tran vdout1_4ck670 FIND v(dout1_4) AT=680.05n

.meas tran vdout1_5ck670 FIND v(dout1_5) AT=680.05n

.meas tran vdout1_6ck670 FIND v(dout1_6) AT=680.05n

.meas tran vdout1_7ck670 FIND v(dout1_7) AT=680.05n

.meas tran vdout1_8ck670 FIND v(dout1_8) AT=680.05n

.meas tran vdout1_9ck670 FIND v(dout1_9) AT=680.05n

.meas tran vdout1_10ck670 FIND v(dout1_10) AT=680.05n

.meas tran vdout1_11ck670 FIND v(dout1_11) AT=680.05n

.meas tran vdout1_12ck670 FIND v(dout1_12) AT=680.05n

.meas tran vdout1_13ck670 FIND v(dout1_13) AT=680.05n

.meas tran vdout1_14ck670 FIND v(dout1_14) AT=680.05n

.meas tran vdout1_15ck670 FIND v(dout1_15) AT=680.05n

.meas tran vdout1_16ck670 FIND v(dout1_16) AT=680.05n

.meas tran vdout1_17ck670 FIND v(dout1_17) AT=680.05n

.meas tran vdout1_18ck670 FIND v(dout1_18) AT=680.05n

.meas tran vdout1_19ck670 FIND v(dout1_19) AT=680.05n

.meas tran vdout1_20ck670 FIND v(dout1_20) AT=680.05n

.meas tran vdout1_21ck670 FIND v(dout1_21) AT=680.05n

.meas tran vdout1_22ck670 FIND v(dout1_22) AT=680.05n

.meas tran vdout1_23ck670 FIND v(dout1_23) AT=680.05n

.meas tran vdout1_24ck670 FIND v(dout1_24) AT=680.05n

.meas tran vdout1_25ck670 FIND v(dout1_25) AT=680.05n

.meas tran vdout1_26ck670 FIND v(dout1_26) AT=680.05n

.meas tran vdout1_27ck670 FIND v(dout1_27) AT=680.05n

.meas tran vdout1_0ck710 FIND v(dout1_0) AT=720.05n

.meas tran vdout1_1ck710 FIND v(dout1_1) AT=720.05n

.meas tran vdout1_2ck710 FIND v(dout1_2) AT=720.05n

.meas tran vdout1_3ck710 FIND v(dout1_3) AT=720.05n

.meas tran vdout1_4ck710 FIND v(dout1_4) AT=720.05n

.meas tran vdout1_5ck710 FIND v(dout1_5) AT=720.05n

.meas tran vdout1_6ck710 FIND v(dout1_6) AT=720.05n

.meas tran vdout1_7ck710 FIND v(dout1_7) AT=720.05n

.meas tran vdout1_8ck710 FIND v(dout1_8) AT=720.05n

.meas tran vdout1_9ck710 FIND v(dout1_9) AT=720.05n

.meas tran vdout1_10ck710 FIND v(dout1_10) AT=720.05n

.meas tran vdout1_11ck710 FIND v(dout1_11) AT=720.05n

.meas tran vdout1_12ck710 FIND v(dout1_12) AT=720.05n

.meas tran vdout1_13ck710 FIND v(dout1_13) AT=720.05n

.meas tran vdout1_14ck710 FIND v(dout1_14) AT=720.05n

.meas tran vdout1_15ck710 FIND v(dout1_15) AT=720.05n

.meas tran vdout1_16ck710 FIND v(dout1_16) AT=720.05n

.meas tran vdout1_17ck710 FIND v(dout1_17) AT=720.05n

.meas tran vdout1_18ck710 FIND v(dout1_18) AT=720.05n

.meas tran vdout1_19ck710 FIND v(dout1_19) AT=720.05n

.meas tran vdout1_20ck710 FIND v(dout1_20) AT=720.05n

.meas tran vdout1_21ck710 FIND v(dout1_21) AT=720.05n

.meas tran vdout1_22ck710 FIND v(dout1_22) AT=720.05n

.meas tran vdout1_23ck710 FIND v(dout1_23) AT=720.05n

.meas tran vdout1_24ck710 FIND v(dout1_24) AT=720.05n

.meas tran vdout1_25ck710 FIND v(dout1_25) AT=720.05n

.meas tran vdout1_26ck710 FIND v(dout1_26) AT=720.05n

.meas tran vdout1_27ck710 FIND v(dout1_27) AT=720.05n

.meas tran vdout1_0ck730 FIND v(dout1_0) AT=740.05n

.meas tran vdout1_1ck730 FIND v(dout1_1) AT=740.05n

.meas tran vdout1_2ck730 FIND v(dout1_2) AT=740.05n

.meas tran vdout1_3ck730 FIND v(dout1_3) AT=740.05n

.meas tran vdout1_4ck730 FIND v(dout1_4) AT=740.05n

.meas tran vdout1_5ck730 FIND v(dout1_5) AT=740.05n

.meas tran vdout1_6ck730 FIND v(dout1_6) AT=740.05n

.meas tran vdout1_7ck730 FIND v(dout1_7) AT=740.05n

.meas tran vdout1_8ck730 FIND v(dout1_8) AT=740.05n

.meas tran vdout1_9ck730 FIND v(dout1_9) AT=740.05n

.meas tran vdout1_10ck730 FIND v(dout1_10) AT=740.05n

.meas tran vdout1_11ck730 FIND v(dout1_11) AT=740.05n

.meas tran vdout1_12ck730 FIND v(dout1_12) AT=740.05n

.meas tran vdout1_13ck730 FIND v(dout1_13) AT=740.05n

.meas tran vdout1_14ck730 FIND v(dout1_14) AT=740.05n

.meas tran vdout1_15ck730 FIND v(dout1_15) AT=740.05n

.meas tran vdout1_16ck730 FIND v(dout1_16) AT=740.05n

.meas tran vdout1_17ck730 FIND v(dout1_17) AT=740.05n

.meas tran vdout1_18ck730 FIND v(dout1_18) AT=740.05n

.meas tran vdout1_19ck730 FIND v(dout1_19) AT=740.05n

.meas tran vdout1_20ck730 FIND v(dout1_20) AT=740.05n

.meas tran vdout1_21ck730 FIND v(dout1_21) AT=740.05n

.meas tran vdout1_22ck730 FIND v(dout1_22) AT=740.05n

.meas tran vdout1_23ck730 FIND v(dout1_23) AT=740.05n

.meas tran vdout1_24ck730 FIND v(dout1_24) AT=740.05n

.meas tran vdout1_25ck730 FIND v(dout1_25) AT=740.05n

.meas tran vdout1_26ck730 FIND v(dout1_26) AT=740.05n

.meas tran vdout1_27ck730 FIND v(dout1_27) AT=740.05n

.meas tran vdout1_0ck750 FIND v(dout1_0) AT=760.05n

.meas tran vdout1_1ck750 FIND v(dout1_1) AT=760.05n

.meas tran vdout1_2ck750 FIND v(dout1_2) AT=760.05n

.meas tran vdout1_3ck750 FIND v(dout1_3) AT=760.05n

.meas tran vdout1_4ck750 FIND v(dout1_4) AT=760.05n

.meas tran vdout1_5ck750 FIND v(dout1_5) AT=760.05n

.meas tran vdout1_6ck750 FIND v(dout1_6) AT=760.05n

.meas tran vdout1_7ck750 FIND v(dout1_7) AT=760.05n

.meas tran vdout1_8ck750 FIND v(dout1_8) AT=760.05n

.meas tran vdout1_9ck750 FIND v(dout1_9) AT=760.05n

.meas tran vdout1_10ck750 FIND v(dout1_10) AT=760.05n

.meas tran vdout1_11ck750 FIND v(dout1_11) AT=760.05n

.meas tran vdout1_12ck750 FIND v(dout1_12) AT=760.05n

.meas tran vdout1_13ck750 FIND v(dout1_13) AT=760.05n

.meas tran vdout1_14ck750 FIND v(dout1_14) AT=760.05n

.meas tran vdout1_15ck750 FIND v(dout1_15) AT=760.05n

.meas tran vdout1_16ck750 FIND v(dout1_16) AT=760.05n

.meas tran vdout1_17ck750 FIND v(dout1_17) AT=760.05n

.meas tran vdout1_18ck750 FIND v(dout1_18) AT=760.05n

.meas tran vdout1_19ck750 FIND v(dout1_19) AT=760.05n

.meas tran vdout1_20ck750 FIND v(dout1_20) AT=760.05n

.meas tran vdout1_21ck750 FIND v(dout1_21) AT=760.05n

.meas tran vdout1_22ck750 FIND v(dout1_22) AT=760.05n

.meas tran vdout1_23ck750 FIND v(dout1_23) AT=760.05n

.meas tran vdout1_24ck750 FIND v(dout1_24) AT=760.05n

.meas tran vdout1_25ck750 FIND v(dout1_25) AT=760.05n

.meas tran vdout1_26ck750 FIND v(dout1_26) AT=760.05n

.meas tran vdout1_27ck750 FIND v(dout1_27) AT=760.05n

.meas tran vdout1_0ck760 FIND v(dout1_0) AT=770.05n

.meas tran vdout1_1ck760 FIND v(dout1_1) AT=770.05n

.meas tran vdout1_2ck760 FIND v(dout1_2) AT=770.05n

.meas tran vdout1_3ck760 FIND v(dout1_3) AT=770.05n

.meas tran vdout1_4ck760 FIND v(dout1_4) AT=770.05n

.meas tran vdout1_5ck760 FIND v(dout1_5) AT=770.05n

.meas tran vdout1_6ck760 FIND v(dout1_6) AT=770.05n

.meas tran vdout1_7ck760 FIND v(dout1_7) AT=770.05n

.meas tran vdout1_8ck760 FIND v(dout1_8) AT=770.05n

.meas tran vdout1_9ck760 FIND v(dout1_9) AT=770.05n

.meas tran vdout1_10ck760 FIND v(dout1_10) AT=770.05n

.meas tran vdout1_11ck760 FIND v(dout1_11) AT=770.05n

.meas tran vdout1_12ck760 FIND v(dout1_12) AT=770.05n

.meas tran vdout1_13ck760 FIND v(dout1_13) AT=770.05n

.meas tran vdout1_14ck760 FIND v(dout1_14) AT=770.05n

.meas tran vdout1_15ck760 FIND v(dout1_15) AT=770.05n

.meas tran vdout1_16ck760 FIND v(dout1_16) AT=770.05n

.meas tran vdout1_17ck760 FIND v(dout1_17) AT=770.05n

.meas tran vdout1_18ck760 FIND v(dout1_18) AT=770.05n

.meas tran vdout1_19ck760 FIND v(dout1_19) AT=770.05n

.meas tran vdout1_20ck760 FIND v(dout1_20) AT=770.05n

.meas tran vdout1_21ck760 FIND v(dout1_21) AT=770.05n

.meas tran vdout1_22ck760 FIND v(dout1_22) AT=770.05n

.meas tran vdout1_23ck760 FIND v(dout1_23) AT=770.05n

.meas tran vdout1_24ck760 FIND v(dout1_24) AT=770.05n

.meas tran vdout1_25ck760 FIND v(dout1_25) AT=770.05n

.meas tran vdout1_26ck760 FIND v(dout1_26) AT=770.05n

.meas tran vdout1_27ck760 FIND v(dout1_27) AT=770.05n

.meas tran vdout1_0ck780 FIND v(dout1_0) AT=790.05n

.meas tran vdout1_1ck780 FIND v(dout1_1) AT=790.05n

.meas tran vdout1_2ck780 FIND v(dout1_2) AT=790.05n

.meas tran vdout1_3ck780 FIND v(dout1_3) AT=790.05n

.meas tran vdout1_4ck780 FIND v(dout1_4) AT=790.05n

.meas tran vdout1_5ck780 FIND v(dout1_5) AT=790.05n

.meas tran vdout1_6ck780 FIND v(dout1_6) AT=790.05n

.meas tran vdout1_7ck780 FIND v(dout1_7) AT=790.05n

.meas tran vdout1_8ck780 FIND v(dout1_8) AT=790.05n

.meas tran vdout1_9ck780 FIND v(dout1_9) AT=790.05n

.meas tran vdout1_10ck780 FIND v(dout1_10) AT=790.05n

.meas tran vdout1_11ck780 FIND v(dout1_11) AT=790.05n

.meas tran vdout1_12ck780 FIND v(dout1_12) AT=790.05n

.meas tran vdout1_13ck780 FIND v(dout1_13) AT=790.05n

.meas tran vdout1_14ck780 FIND v(dout1_14) AT=790.05n

.meas tran vdout1_15ck780 FIND v(dout1_15) AT=790.05n

.meas tran vdout1_16ck780 FIND v(dout1_16) AT=790.05n

.meas tran vdout1_17ck780 FIND v(dout1_17) AT=790.05n

.meas tran vdout1_18ck780 FIND v(dout1_18) AT=790.05n

.meas tran vdout1_19ck780 FIND v(dout1_19) AT=790.05n

.meas tran vdout1_20ck780 FIND v(dout1_20) AT=790.05n

.meas tran vdout1_21ck780 FIND v(dout1_21) AT=790.05n

.meas tran vdout1_22ck780 FIND v(dout1_22) AT=790.05n

.meas tran vdout1_23ck780 FIND v(dout1_23) AT=790.05n

.meas tran vdout1_24ck780 FIND v(dout1_24) AT=790.05n

.meas tran vdout1_25ck780 FIND v(dout1_25) AT=790.05n

.meas tran vdout1_26ck780 FIND v(dout1_26) AT=790.05n

.meas tran vdout1_27ck780 FIND v(dout1_27) AT=790.05n

.meas tran vdout1_0ck790 FIND v(dout1_0) AT=800.05n

.meas tran vdout1_1ck790 FIND v(dout1_1) AT=800.05n

.meas tran vdout1_2ck790 FIND v(dout1_2) AT=800.05n

.meas tran vdout1_3ck790 FIND v(dout1_3) AT=800.05n

.meas tran vdout1_4ck790 FIND v(dout1_4) AT=800.05n

.meas tran vdout1_5ck790 FIND v(dout1_5) AT=800.05n

.meas tran vdout1_6ck790 FIND v(dout1_6) AT=800.05n

.meas tran vdout1_7ck790 FIND v(dout1_7) AT=800.05n

.meas tran vdout1_8ck790 FIND v(dout1_8) AT=800.05n

.meas tran vdout1_9ck790 FIND v(dout1_9) AT=800.05n

.meas tran vdout1_10ck790 FIND v(dout1_10) AT=800.05n

.meas tran vdout1_11ck790 FIND v(dout1_11) AT=800.05n

.meas tran vdout1_12ck790 FIND v(dout1_12) AT=800.05n

.meas tran vdout1_13ck790 FIND v(dout1_13) AT=800.05n

.meas tran vdout1_14ck790 FIND v(dout1_14) AT=800.05n

.meas tran vdout1_15ck790 FIND v(dout1_15) AT=800.05n

.meas tran vdout1_16ck790 FIND v(dout1_16) AT=800.05n

.meas tran vdout1_17ck790 FIND v(dout1_17) AT=800.05n

.meas tran vdout1_18ck790 FIND v(dout1_18) AT=800.05n

.meas tran vdout1_19ck790 FIND v(dout1_19) AT=800.05n

.meas tran vdout1_20ck790 FIND v(dout1_20) AT=800.05n

.meas tran vdout1_21ck790 FIND v(dout1_21) AT=800.05n

.meas tran vdout1_22ck790 FIND v(dout1_22) AT=800.05n

.meas tran vdout1_23ck790 FIND v(dout1_23) AT=800.05n

.meas tran vdout1_24ck790 FIND v(dout1_24) AT=800.05n

.meas tran vdout1_25ck790 FIND v(dout1_25) AT=800.05n

.meas tran vdout1_26ck790 FIND v(dout1_26) AT=800.05n

.meas tran vdout1_27ck790 FIND v(dout1_27) AT=800.05n

.meas tran vdout1_0ck800 FIND v(dout1_0) AT=810.05n

.meas tran vdout1_1ck800 FIND v(dout1_1) AT=810.05n

.meas tran vdout1_2ck800 FIND v(dout1_2) AT=810.05n

.meas tran vdout1_3ck800 FIND v(dout1_3) AT=810.05n

.meas tran vdout1_4ck800 FIND v(dout1_4) AT=810.05n

.meas tran vdout1_5ck800 FIND v(dout1_5) AT=810.05n

.meas tran vdout1_6ck800 FIND v(dout1_6) AT=810.05n

.meas tran vdout1_7ck800 FIND v(dout1_7) AT=810.05n

.meas tran vdout1_8ck800 FIND v(dout1_8) AT=810.05n

.meas tran vdout1_9ck800 FIND v(dout1_9) AT=810.05n

.meas tran vdout1_10ck800 FIND v(dout1_10) AT=810.05n

.meas tran vdout1_11ck800 FIND v(dout1_11) AT=810.05n

.meas tran vdout1_12ck800 FIND v(dout1_12) AT=810.05n

.meas tran vdout1_13ck800 FIND v(dout1_13) AT=810.05n

.meas tran vdout1_14ck800 FIND v(dout1_14) AT=810.05n

.meas tran vdout1_15ck800 FIND v(dout1_15) AT=810.05n

.meas tran vdout1_16ck800 FIND v(dout1_16) AT=810.05n

.meas tran vdout1_17ck800 FIND v(dout1_17) AT=810.05n

.meas tran vdout1_18ck800 FIND v(dout1_18) AT=810.05n

.meas tran vdout1_19ck800 FIND v(dout1_19) AT=810.05n

.meas tran vdout1_20ck800 FIND v(dout1_20) AT=810.05n

.meas tran vdout1_21ck800 FIND v(dout1_21) AT=810.05n

.meas tran vdout1_22ck800 FIND v(dout1_22) AT=810.05n

.meas tran vdout1_23ck800 FIND v(dout1_23) AT=810.05n

.meas tran vdout1_24ck800 FIND v(dout1_24) AT=810.05n

.meas tran vdout1_25ck800 FIND v(dout1_25) AT=810.05n

.meas tran vdout1_26ck800 FIND v(dout1_26) AT=810.05n

.meas tran vdout1_27ck800 FIND v(dout1_27) AT=810.05n

.meas tran vdout1_0ck820 FIND v(dout1_0) AT=830.05n

.meas tran vdout1_1ck820 FIND v(dout1_1) AT=830.05n

.meas tran vdout1_2ck820 FIND v(dout1_2) AT=830.05n

.meas tran vdout1_3ck820 FIND v(dout1_3) AT=830.05n

.meas tran vdout1_4ck820 FIND v(dout1_4) AT=830.05n

.meas tran vdout1_5ck820 FIND v(dout1_5) AT=830.05n

.meas tran vdout1_6ck820 FIND v(dout1_6) AT=830.05n

.meas tran vdout1_7ck820 FIND v(dout1_7) AT=830.05n

.meas tran vdout1_8ck820 FIND v(dout1_8) AT=830.05n

.meas tran vdout1_9ck820 FIND v(dout1_9) AT=830.05n

.meas tran vdout1_10ck820 FIND v(dout1_10) AT=830.05n

.meas tran vdout1_11ck820 FIND v(dout1_11) AT=830.05n

.meas tran vdout1_12ck820 FIND v(dout1_12) AT=830.05n

.meas tran vdout1_13ck820 FIND v(dout1_13) AT=830.05n

.meas tran vdout1_14ck820 FIND v(dout1_14) AT=830.05n

.meas tran vdout1_15ck820 FIND v(dout1_15) AT=830.05n

.meas tran vdout1_16ck820 FIND v(dout1_16) AT=830.05n

.meas tran vdout1_17ck820 FIND v(dout1_17) AT=830.05n

.meas tran vdout1_18ck820 FIND v(dout1_18) AT=830.05n

.meas tran vdout1_19ck820 FIND v(dout1_19) AT=830.05n

.meas tran vdout1_20ck820 FIND v(dout1_20) AT=830.05n

.meas tran vdout1_21ck820 FIND v(dout1_21) AT=830.05n

.meas tran vdout1_22ck820 FIND v(dout1_22) AT=830.05n

.meas tran vdout1_23ck820 FIND v(dout1_23) AT=830.05n

.meas tran vdout1_24ck820 FIND v(dout1_24) AT=830.05n

.meas tran vdout1_25ck820 FIND v(dout1_25) AT=830.05n

.meas tran vdout1_26ck820 FIND v(dout1_26) AT=830.05n

.meas tran vdout1_27ck820 FIND v(dout1_27) AT=830.05n

.meas tran vdout1_0ck840 FIND v(dout1_0) AT=850.05n

.meas tran vdout1_1ck840 FIND v(dout1_1) AT=850.05n

.meas tran vdout1_2ck840 FIND v(dout1_2) AT=850.05n

.meas tran vdout1_3ck840 FIND v(dout1_3) AT=850.05n

.meas tran vdout1_4ck840 FIND v(dout1_4) AT=850.05n

.meas tran vdout1_5ck840 FIND v(dout1_5) AT=850.05n

.meas tran vdout1_6ck840 FIND v(dout1_6) AT=850.05n

.meas tran vdout1_7ck840 FIND v(dout1_7) AT=850.05n

.meas tran vdout1_8ck840 FIND v(dout1_8) AT=850.05n

.meas tran vdout1_9ck840 FIND v(dout1_9) AT=850.05n

.meas tran vdout1_10ck840 FIND v(dout1_10) AT=850.05n

.meas tran vdout1_11ck840 FIND v(dout1_11) AT=850.05n

.meas tran vdout1_12ck840 FIND v(dout1_12) AT=850.05n

.meas tran vdout1_13ck840 FIND v(dout1_13) AT=850.05n

.meas tran vdout1_14ck840 FIND v(dout1_14) AT=850.05n

.meas tran vdout1_15ck840 FIND v(dout1_15) AT=850.05n

.meas tran vdout1_16ck840 FIND v(dout1_16) AT=850.05n

.meas tran vdout1_17ck840 FIND v(dout1_17) AT=850.05n

.meas tran vdout1_18ck840 FIND v(dout1_18) AT=850.05n

.meas tran vdout1_19ck840 FIND v(dout1_19) AT=850.05n

.meas tran vdout1_20ck840 FIND v(dout1_20) AT=850.05n

.meas tran vdout1_21ck840 FIND v(dout1_21) AT=850.05n

.meas tran vdout1_22ck840 FIND v(dout1_22) AT=850.05n

.meas tran vdout1_23ck840 FIND v(dout1_23) AT=850.05n

.meas tran vdout1_24ck840 FIND v(dout1_24) AT=850.05n

.meas tran vdout1_25ck840 FIND v(dout1_25) AT=850.05n

.meas tran vdout1_26ck840 FIND v(dout1_26) AT=850.05n

.meas tran vdout1_27ck840 FIND v(dout1_27) AT=850.05n

.meas tran vdout1_0ck850 FIND v(dout1_0) AT=860.05n

.meas tran vdout1_1ck850 FIND v(dout1_1) AT=860.05n

.meas tran vdout1_2ck850 FIND v(dout1_2) AT=860.05n

.meas tran vdout1_3ck850 FIND v(dout1_3) AT=860.05n

.meas tran vdout1_4ck850 FIND v(dout1_4) AT=860.05n

.meas tran vdout1_5ck850 FIND v(dout1_5) AT=860.05n

.meas tran vdout1_6ck850 FIND v(dout1_6) AT=860.05n

.meas tran vdout1_7ck850 FIND v(dout1_7) AT=860.05n

.meas tran vdout1_8ck850 FIND v(dout1_8) AT=860.05n

.meas tran vdout1_9ck850 FIND v(dout1_9) AT=860.05n

.meas tran vdout1_10ck850 FIND v(dout1_10) AT=860.05n

.meas tran vdout1_11ck850 FIND v(dout1_11) AT=860.05n

.meas tran vdout1_12ck850 FIND v(dout1_12) AT=860.05n

.meas tran vdout1_13ck850 FIND v(dout1_13) AT=860.05n

.meas tran vdout1_14ck850 FIND v(dout1_14) AT=860.05n

.meas tran vdout1_15ck850 FIND v(dout1_15) AT=860.05n

.meas tran vdout1_16ck850 FIND v(dout1_16) AT=860.05n

.meas tran vdout1_17ck850 FIND v(dout1_17) AT=860.05n

.meas tran vdout1_18ck850 FIND v(dout1_18) AT=860.05n

.meas tran vdout1_19ck850 FIND v(dout1_19) AT=860.05n

.meas tran vdout1_20ck850 FIND v(dout1_20) AT=860.05n

.meas tran vdout1_21ck850 FIND v(dout1_21) AT=860.05n

.meas tran vdout1_22ck850 FIND v(dout1_22) AT=860.05n

.meas tran vdout1_23ck850 FIND v(dout1_23) AT=860.05n

.meas tran vdout1_24ck850 FIND v(dout1_24) AT=860.05n

.meas tran vdout1_25ck850 FIND v(dout1_25) AT=860.05n

.meas tran vdout1_26ck850 FIND v(dout1_26) AT=860.05n

.meas tran vdout1_27ck850 FIND v(dout1_27) AT=860.05n

.meas tran vdout1_0ck870 FIND v(dout1_0) AT=880.05n

.meas tran vdout1_1ck870 FIND v(dout1_1) AT=880.05n

.meas tran vdout1_2ck870 FIND v(dout1_2) AT=880.05n

.meas tran vdout1_3ck870 FIND v(dout1_3) AT=880.05n

.meas tran vdout1_4ck870 FIND v(dout1_4) AT=880.05n

.meas tran vdout1_5ck870 FIND v(dout1_5) AT=880.05n

.meas tran vdout1_6ck870 FIND v(dout1_6) AT=880.05n

.meas tran vdout1_7ck870 FIND v(dout1_7) AT=880.05n

.meas tran vdout1_8ck870 FIND v(dout1_8) AT=880.05n

.meas tran vdout1_9ck870 FIND v(dout1_9) AT=880.05n

.meas tran vdout1_10ck870 FIND v(dout1_10) AT=880.05n

.meas tran vdout1_11ck870 FIND v(dout1_11) AT=880.05n

.meas tran vdout1_12ck870 FIND v(dout1_12) AT=880.05n

.meas tran vdout1_13ck870 FIND v(dout1_13) AT=880.05n

.meas tran vdout1_14ck870 FIND v(dout1_14) AT=880.05n

.meas tran vdout1_15ck870 FIND v(dout1_15) AT=880.05n

.meas tran vdout1_16ck870 FIND v(dout1_16) AT=880.05n

.meas tran vdout1_17ck870 FIND v(dout1_17) AT=880.05n

.meas tran vdout1_18ck870 FIND v(dout1_18) AT=880.05n

.meas tran vdout1_19ck870 FIND v(dout1_19) AT=880.05n

.meas tran vdout1_20ck870 FIND v(dout1_20) AT=880.05n

.meas tran vdout1_21ck870 FIND v(dout1_21) AT=880.05n

.meas tran vdout1_22ck870 FIND v(dout1_22) AT=880.05n

.meas tran vdout1_23ck870 FIND v(dout1_23) AT=880.05n

.meas tran vdout1_24ck870 FIND v(dout1_24) AT=880.05n

.meas tran vdout1_25ck870 FIND v(dout1_25) AT=880.05n

.meas tran vdout1_26ck870 FIND v(dout1_26) AT=880.05n

.meas tran vdout1_27ck870 FIND v(dout1_27) AT=880.05n

.meas tran vdout1_0ck880 FIND v(dout1_0) AT=890.05n

.meas tran vdout1_1ck880 FIND v(dout1_1) AT=890.05n

.meas tran vdout1_2ck880 FIND v(dout1_2) AT=890.05n

.meas tran vdout1_3ck880 FIND v(dout1_3) AT=890.05n

.meas tran vdout1_4ck880 FIND v(dout1_4) AT=890.05n

.meas tran vdout1_5ck880 FIND v(dout1_5) AT=890.05n

.meas tran vdout1_6ck880 FIND v(dout1_6) AT=890.05n

.meas tran vdout1_7ck880 FIND v(dout1_7) AT=890.05n

.meas tran vdout1_8ck880 FIND v(dout1_8) AT=890.05n

.meas tran vdout1_9ck880 FIND v(dout1_9) AT=890.05n

.meas tran vdout1_10ck880 FIND v(dout1_10) AT=890.05n

.meas tran vdout1_11ck880 FIND v(dout1_11) AT=890.05n

.meas tran vdout1_12ck880 FIND v(dout1_12) AT=890.05n

.meas tran vdout1_13ck880 FIND v(dout1_13) AT=890.05n

.meas tran vdout1_14ck880 FIND v(dout1_14) AT=890.05n

.meas tran vdout1_15ck880 FIND v(dout1_15) AT=890.05n

.meas tran vdout1_16ck880 FIND v(dout1_16) AT=890.05n

.meas tran vdout1_17ck880 FIND v(dout1_17) AT=890.05n

.meas tran vdout1_18ck880 FIND v(dout1_18) AT=890.05n

.meas tran vdout1_19ck880 FIND v(dout1_19) AT=890.05n

.meas tran vdout1_20ck880 FIND v(dout1_20) AT=890.05n

.meas tran vdout1_21ck880 FIND v(dout1_21) AT=890.05n

.meas tran vdout1_22ck880 FIND v(dout1_22) AT=890.05n

.meas tran vdout1_23ck880 FIND v(dout1_23) AT=890.05n

.meas tran vdout1_24ck880 FIND v(dout1_24) AT=890.05n

.meas tran vdout1_25ck880 FIND v(dout1_25) AT=890.05n

.meas tran vdout1_26ck880 FIND v(dout1_26) AT=890.05n

.meas tran vdout1_27ck880 FIND v(dout1_27) AT=890.05n

.meas tran vdout1_0ck890 FIND v(dout1_0) AT=900.05n

.meas tran vdout1_1ck890 FIND v(dout1_1) AT=900.05n

.meas tran vdout1_2ck890 FIND v(dout1_2) AT=900.05n

.meas tran vdout1_3ck890 FIND v(dout1_3) AT=900.05n

.meas tran vdout1_4ck890 FIND v(dout1_4) AT=900.05n

.meas tran vdout1_5ck890 FIND v(dout1_5) AT=900.05n

.meas tran vdout1_6ck890 FIND v(dout1_6) AT=900.05n

.meas tran vdout1_7ck890 FIND v(dout1_7) AT=900.05n

.meas tran vdout1_8ck890 FIND v(dout1_8) AT=900.05n

.meas tran vdout1_9ck890 FIND v(dout1_9) AT=900.05n

.meas tran vdout1_10ck890 FIND v(dout1_10) AT=900.05n

.meas tran vdout1_11ck890 FIND v(dout1_11) AT=900.05n

.meas tran vdout1_12ck890 FIND v(dout1_12) AT=900.05n

.meas tran vdout1_13ck890 FIND v(dout1_13) AT=900.05n

.meas tran vdout1_14ck890 FIND v(dout1_14) AT=900.05n

.meas tran vdout1_15ck890 FIND v(dout1_15) AT=900.05n

.meas tran vdout1_16ck890 FIND v(dout1_16) AT=900.05n

.meas tran vdout1_17ck890 FIND v(dout1_17) AT=900.05n

.meas tran vdout1_18ck890 FIND v(dout1_18) AT=900.05n

.meas tran vdout1_19ck890 FIND v(dout1_19) AT=900.05n

.meas tran vdout1_20ck890 FIND v(dout1_20) AT=900.05n

.meas tran vdout1_21ck890 FIND v(dout1_21) AT=900.05n

.meas tran vdout1_22ck890 FIND v(dout1_22) AT=900.05n

.meas tran vdout1_23ck890 FIND v(dout1_23) AT=900.05n

.meas tran vdout1_24ck890 FIND v(dout1_24) AT=900.05n

.meas tran vdout1_25ck890 FIND v(dout1_25) AT=900.05n

.meas tran vdout1_26ck890 FIND v(dout1_26) AT=900.05n

.meas tran vdout1_27ck890 FIND v(dout1_27) AT=900.05n

.meas tran vdout1_0ck910 FIND v(dout1_0) AT=920.05n

.meas tran vdout1_1ck910 FIND v(dout1_1) AT=920.05n

.meas tran vdout1_2ck910 FIND v(dout1_2) AT=920.05n

.meas tran vdout1_3ck910 FIND v(dout1_3) AT=920.05n

.meas tran vdout1_4ck910 FIND v(dout1_4) AT=920.05n

.meas tran vdout1_5ck910 FIND v(dout1_5) AT=920.05n

.meas tran vdout1_6ck910 FIND v(dout1_6) AT=920.05n

.meas tran vdout1_7ck910 FIND v(dout1_7) AT=920.05n

.meas tran vdout1_8ck910 FIND v(dout1_8) AT=920.05n

.meas tran vdout1_9ck910 FIND v(dout1_9) AT=920.05n

.meas tran vdout1_10ck910 FIND v(dout1_10) AT=920.05n

.meas tran vdout1_11ck910 FIND v(dout1_11) AT=920.05n

.meas tran vdout1_12ck910 FIND v(dout1_12) AT=920.05n

.meas tran vdout1_13ck910 FIND v(dout1_13) AT=920.05n

.meas tran vdout1_14ck910 FIND v(dout1_14) AT=920.05n

.meas tran vdout1_15ck910 FIND v(dout1_15) AT=920.05n

.meas tran vdout1_16ck910 FIND v(dout1_16) AT=920.05n

.meas tran vdout1_17ck910 FIND v(dout1_17) AT=920.05n

.meas tran vdout1_18ck910 FIND v(dout1_18) AT=920.05n

.meas tran vdout1_19ck910 FIND v(dout1_19) AT=920.05n

.meas tran vdout1_20ck910 FIND v(dout1_20) AT=920.05n

.meas tran vdout1_21ck910 FIND v(dout1_21) AT=920.05n

.meas tran vdout1_22ck910 FIND v(dout1_22) AT=920.05n

.meas tran vdout1_23ck910 FIND v(dout1_23) AT=920.05n

.meas tran vdout1_24ck910 FIND v(dout1_24) AT=920.05n

.meas tran vdout1_25ck910 FIND v(dout1_25) AT=920.05n

.meas tran vdout1_26ck910 FIND v(dout1_26) AT=920.05n

.meas tran vdout1_27ck910 FIND v(dout1_27) AT=920.05n

.meas tran vdout1_0ck920 FIND v(dout1_0) AT=930.05n

.meas tran vdout1_1ck920 FIND v(dout1_1) AT=930.05n

.meas tran vdout1_2ck920 FIND v(dout1_2) AT=930.05n

.meas tran vdout1_3ck920 FIND v(dout1_3) AT=930.05n

.meas tran vdout1_4ck920 FIND v(dout1_4) AT=930.05n

.meas tran vdout1_5ck920 FIND v(dout1_5) AT=930.05n

.meas tran vdout1_6ck920 FIND v(dout1_6) AT=930.05n

.meas tran vdout1_7ck920 FIND v(dout1_7) AT=930.05n

.meas tran vdout1_8ck920 FIND v(dout1_8) AT=930.05n

.meas tran vdout1_9ck920 FIND v(dout1_9) AT=930.05n

.meas tran vdout1_10ck920 FIND v(dout1_10) AT=930.05n

.meas tran vdout1_11ck920 FIND v(dout1_11) AT=930.05n

.meas tran vdout1_12ck920 FIND v(dout1_12) AT=930.05n

.meas tran vdout1_13ck920 FIND v(dout1_13) AT=930.05n

.meas tran vdout1_14ck920 FIND v(dout1_14) AT=930.05n

.meas tran vdout1_15ck920 FIND v(dout1_15) AT=930.05n

.meas tran vdout1_16ck920 FIND v(dout1_16) AT=930.05n

.meas tran vdout1_17ck920 FIND v(dout1_17) AT=930.05n

.meas tran vdout1_18ck920 FIND v(dout1_18) AT=930.05n

.meas tran vdout1_19ck920 FIND v(dout1_19) AT=930.05n

.meas tran vdout1_20ck920 FIND v(dout1_20) AT=930.05n

.meas tran vdout1_21ck920 FIND v(dout1_21) AT=930.05n

.meas tran vdout1_22ck920 FIND v(dout1_22) AT=930.05n

.meas tran vdout1_23ck920 FIND v(dout1_23) AT=930.05n

.meas tran vdout1_24ck920 FIND v(dout1_24) AT=930.05n

.meas tran vdout1_25ck920 FIND v(dout1_25) AT=930.05n

.meas tran vdout1_26ck920 FIND v(dout1_26) AT=930.05n

.meas tran vdout1_27ck920 FIND v(dout1_27) AT=930.05n

.meas tran vdout1_0ck940 FIND v(dout1_0) AT=950.05n

.meas tran vdout1_1ck940 FIND v(dout1_1) AT=950.05n

.meas tran vdout1_2ck940 FIND v(dout1_2) AT=950.05n

.meas tran vdout1_3ck940 FIND v(dout1_3) AT=950.05n

.meas tran vdout1_4ck940 FIND v(dout1_4) AT=950.05n

.meas tran vdout1_5ck940 FIND v(dout1_5) AT=950.05n

.meas tran vdout1_6ck940 FIND v(dout1_6) AT=950.05n

.meas tran vdout1_7ck940 FIND v(dout1_7) AT=950.05n

.meas tran vdout1_8ck940 FIND v(dout1_8) AT=950.05n

.meas tran vdout1_9ck940 FIND v(dout1_9) AT=950.05n

.meas tran vdout1_10ck940 FIND v(dout1_10) AT=950.05n

.meas tran vdout1_11ck940 FIND v(dout1_11) AT=950.05n

.meas tran vdout1_12ck940 FIND v(dout1_12) AT=950.05n

.meas tran vdout1_13ck940 FIND v(dout1_13) AT=950.05n

.meas tran vdout1_14ck940 FIND v(dout1_14) AT=950.05n

.meas tran vdout1_15ck940 FIND v(dout1_15) AT=950.05n

.meas tran vdout1_16ck940 FIND v(dout1_16) AT=950.05n

.meas tran vdout1_17ck940 FIND v(dout1_17) AT=950.05n

.meas tran vdout1_18ck940 FIND v(dout1_18) AT=950.05n

.meas tran vdout1_19ck940 FIND v(dout1_19) AT=950.05n

.meas tran vdout1_20ck940 FIND v(dout1_20) AT=950.05n

.meas tran vdout1_21ck940 FIND v(dout1_21) AT=950.05n

.meas tran vdout1_22ck940 FIND v(dout1_22) AT=950.05n

.meas tran vdout1_23ck940 FIND v(dout1_23) AT=950.05n

.meas tran vdout1_24ck940 FIND v(dout1_24) AT=950.05n

.meas tran vdout1_25ck940 FIND v(dout1_25) AT=950.05n

.meas tran vdout1_26ck940 FIND v(dout1_26) AT=950.05n

.meas tran vdout1_27ck940 FIND v(dout1_27) AT=950.05n

.meas tran vdout1_0ck950 FIND v(dout1_0) AT=960.05n

.meas tran vdout1_1ck950 FIND v(dout1_1) AT=960.05n

.meas tran vdout1_2ck950 FIND v(dout1_2) AT=960.05n

.meas tran vdout1_3ck950 FIND v(dout1_3) AT=960.05n

.meas tran vdout1_4ck950 FIND v(dout1_4) AT=960.05n

.meas tran vdout1_5ck950 FIND v(dout1_5) AT=960.05n

.meas tran vdout1_6ck950 FIND v(dout1_6) AT=960.05n

.meas tran vdout1_7ck950 FIND v(dout1_7) AT=960.05n

.meas tran vdout1_8ck950 FIND v(dout1_8) AT=960.05n

.meas tran vdout1_9ck950 FIND v(dout1_9) AT=960.05n

.meas tran vdout1_10ck950 FIND v(dout1_10) AT=960.05n

.meas tran vdout1_11ck950 FIND v(dout1_11) AT=960.05n

.meas tran vdout1_12ck950 FIND v(dout1_12) AT=960.05n

.meas tran vdout1_13ck950 FIND v(dout1_13) AT=960.05n

.meas tran vdout1_14ck950 FIND v(dout1_14) AT=960.05n

.meas tran vdout1_15ck950 FIND v(dout1_15) AT=960.05n

.meas tran vdout1_16ck950 FIND v(dout1_16) AT=960.05n

.meas tran vdout1_17ck950 FIND v(dout1_17) AT=960.05n

.meas tran vdout1_18ck950 FIND v(dout1_18) AT=960.05n

.meas tran vdout1_19ck950 FIND v(dout1_19) AT=960.05n

.meas tran vdout1_20ck950 FIND v(dout1_20) AT=960.05n

.meas tran vdout1_21ck950 FIND v(dout1_21) AT=960.05n

.meas tran vdout1_22ck950 FIND v(dout1_22) AT=960.05n

.meas tran vdout1_23ck950 FIND v(dout1_23) AT=960.05n

.meas tran vdout1_24ck950 FIND v(dout1_24) AT=960.05n

.meas tran vdout1_25ck950 FIND v(dout1_25) AT=960.05n

.meas tran vdout1_26ck950 FIND v(dout1_26) AT=960.05n

.meas tran vdout1_27ck950 FIND v(dout1_27) AT=960.05n

.meas tran vdout1_0ck1030 FIND v(dout1_0) AT=1040.05n

.meas tran vdout1_1ck1030 FIND v(dout1_1) AT=1040.05n

.meas tran vdout1_2ck1030 FIND v(dout1_2) AT=1040.05n

.meas tran vdout1_3ck1030 FIND v(dout1_3) AT=1040.05n

.meas tran vdout1_4ck1030 FIND v(dout1_4) AT=1040.05n

.meas tran vdout1_5ck1030 FIND v(dout1_5) AT=1040.05n

.meas tran vdout1_6ck1030 FIND v(dout1_6) AT=1040.05n

.meas tran vdout1_7ck1030 FIND v(dout1_7) AT=1040.05n

.meas tran vdout1_8ck1030 FIND v(dout1_8) AT=1040.05n

.meas tran vdout1_9ck1030 FIND v(dout1_9) AT=1040.05n

.meas tran vdout1_10ck1030 FIND v(dout1_10) AT=1040.05n

.meas tran vdout1_11ck1030 FIND v(dout1_11) AT=1040.05n

.meas tran vdout1_12ck1030 FIND v(dout1_12) AT=1040.05n

.meas tran vdout1_13ck1030 FIND v(dout1_13) AT=1040.05n

.meas tran vdout1_14ck1030 FIND v(dout1_14) AT=1040.05n

.meas tran vdout1_15ck1030 FIND v(dout1_15) AT=1040.05n

.meas tran vdout1_16ck1030 FIND v(dout1_16) AT=1040.05n

.meas tran vdout1_17ck1030 FIND v(dout1_17) AT=1040.05n

.meas tran vdout1_18ck1030 FIND v(dout1_18) AT=1040.05n

.meas tran vdout1_19ck1030 FIND v(dout1_19) AT=1040.05n

.meas tran vdout1_20ck1030 FIND v(dout1_20) AT=1040.05n

.meas tran vdout1_21ck1030 FIND v(dout1_21) AT=1040.05n

.meas tran vdout1_22ck1030 FIND v(dout1_22) AT=1040.05n

.meas tran vdout1_23ck1030 FIND v(dout1_23) AT=1040.05n

.meas tran vdout1_24ck1030 FIND v(dout1_24) AT=1040.05n

.meas tran vdout1_25ck1030 FIND v(dout1_25) AT=1040.05n

.meas tran vdout1_26ck1030 FIND v(dout1_26) AT=1040.05n

.meas tran vdout1_27ck1030 FIND v(dout1_27) AT=1040.05n

.meas tran vdout1_0ck1040 FIND v(dout1_0) AT=1050.05n

.meas tran vdout1_1ck1040 FIND v(dout1_1) AT=1050.05n

.meas tran vdout1_2ck1040 FIND v(dout1_2) AT=1050.05n

.meas tran vdout1_3ck1040 FIND v(dout1_3) AT=1050.05n

.meas tran vdout1_4ck1040 FIND v(dout1_4) AT=1050.05n

.meas tran vdout1_5ck1040 FIND v(dout1_5) AT=1050.05n

.meas tran vdout1_6ck1040 FIND v(dout1_6) AT=1050.05n

.meas tran vdout1_7ck1040 FIND v(dout1_7) AT=1050.05n

.meas tran vdout1_8ck1040 FIND v(dout1_8) AT=1050.05n

.meas tran vdout1_9ck1040 FIND v(dout1_9) AT=1050.05n

.meas tran vdout1_10ck1040 FIND v(dout1_10) AT=1050.05n

.meas tran vdout1_11ck1040 FIND v(dout1_11) AT=1050.05n

.meas tran vdout1_12ck1040 FIND v(dout1_12) AT=1050.05n

.meas tran vdout1_13ck1040 FIND v(dout1_13) AT=1050.05n

.meas tran vdout1_14ck1040 FIND v(dout1_14) AT=1050.05n

.meas tran vdout1_15ck1040 FIND v(dout1_15) AT=1050.05n

.meas tran vdout1_16ck1040 FIND v(dout1_16) AT=1050.05n

.meas tran vdout1_17ck1040 FIND v(dout1_17) AT=1050.05n

.meas tran vdout1_18ck1040 FIND v(dout1_18) AT=1050.05n

.meas tran vdout1_19ck1040 FIND v(dout1_19) AT=1050.05n

.meas tran vdout1_20ck1040 FIND v(dout1_20) AT=1050.05n

.meas tran vdout1_21ck1040 FIND v(dout1_21) AT=1050.05n

.meas tran vdout1_22ck1040 FIND v(dout1_22) AT=1050.05n

.meas tran vdout1_23ck1040 FIND v(dout1_23) AT=1050.05n

.meas tran vdout1_24ck1040 FIND v(dout1_24) AT=1050.05n

.meas tran vdout1_25ck1040 FIND v(dout1_25) AT=1050.05n

.meas tran vdout1_26ck1040 FIND v(dout1_26) AT=1050.05n

.meas tran vdout1_27ck1040 FIND v(dout1_27) AT=1050.05n

.meas tran vdout1_0ck1080 FIND v(dout1_0) AT=1090.05n

.meas tran vdout1_1ck1080 FIND v(dout1_1) AT=1090.05n

.meas tran vdout1_2ck1080 FIND v(dout1_2) AT=1090.05n

.meas tran vdout1_3ck1080 FIND v(dout1_3) AT=1090.05n

.meas tran vdout1_4ck1080 FIND v(dout1_4) AT=1090.05n

.meas tran vdout1_5ck1080 FIND v(dout1_5) AT=1090.05n

.meas tran vdout1_6ck1080 FIND v(dout1_6) AT=1090.05n

.meas tran vdout1_7ck1080 FIND v(dout1_7) AT=1090.05n

.meas tran vdout1_8ck1080 FIND v(dout1_8) AT=1090.05n

.meas tran vdout1_9ck1080 FIND v(dout1_9) AT=1090.05n

.meas tran vdout1_10ck1080 FIND v(dout1_10) AT=1090.05n

.meas tran vdout1_11ck1080 FIND v(dout1_11) AT=1090.05n

.meas tran vdout1_12ck1080 FIND v(dout1_12) AT=1090.05n

.meas tran vdout1_13ck1080 FIND v(dout1_13) AT=1090.05n

.meas tran vdout1_14ck1080 FIND v(dout1_14) AT=1090.05n

.meas tran vdout1_15ck1080 FIND v(dout1_15) AT=1090.05n

.meas tran vdout1_16ck1080 FIND v(dout1_16) AT=1090.05n

.meas tran vdout1_17ck1080 FIND v(dout1_17) AT=1090.05n

.meas tran vdout1_18ck1080 FIND v(dout1_18) AT=1090.05n

.meas tran vdout1_19ck1080 FIND v(dout1_19) AT=1090.05n

.meas tran vdout1_20ck1080 FIND v(dout1_20) AT=1090.05n

.meas tran vdout1_21ck1080 FIND v(dout1_21) AT=1090.05n

.meas tran vdout1_22ck1080 FIND v(dout1_22) AT=1090.05n

.meas tran vdout1_23ck1080 FIND v(dout1_23) AT=1090.05n

.meas tran vdout1_24ck1080 FIND v(dout1_24) AT=1090.05n

.meas tran vdout1_25ck1080 FIND v(dout1_25) AT=1090.05n

.meas tran vdout1_26ck1080 FIND v(dout1_26) AT=1090.05n

.meas tran vdout1_27ck1080 FIND v(dout1_27) AT=1090.05n

.meas tran vdout1_0ck1130 FIND v(dout1_0) AT=1140.05n

.meas tran vdout1_1ck1130 FIND v(dout1_1) AT=1140.05n

.meas tran vdout1_2ck1130 FIND v(dout1_2) AT=1140.05n

.meas tran vdout1_3ck1130 FIND v(dout1_3) AT=1140.05n

.meas tran vdout1_4ck1130 FIND v(dout1_4) AT=1140.05n

.meas tran vdout1_5ck1130 FIND v(dout1_5) AT=1140.05n

.meas tran vdout1_6ck1130 FIND v(dout1_6) AT=1140.05n

.meas tran vdout1_7ck1130 FIND v(dout1_7) AT=1140.05n

.meas tran vdout1_8ck1130 FIND v(dout1_8) AT=1140.05n

.meas tran vdout1_9ck1130 FIND v(dout1_9) AT=1140.05n

.meas tran vdout1_10ck1130 FIND v(dout1_10) AT=1140.05n

.meas tran vdout1_11ck1130 FIND v(dout1_11) AT=1140.05n

.meas tran vdout1_12ck1130 FIND v(dout1_12) AT=1140.05n

.meas tran vdout1_13ck1130 FIND v(dout1_13) AT=1140.05n

.meas tran vdout1_14ck1130 FIND v(dout1_14) AT=1140.05n

.meas tran vdout1_15ck1130 FIND v(dout1_15) AT=1140.05n

.meas tran vdout1_16ck1130 FIND v(dout1_16) AT=1140.05n

.meas tran vdout1_17ck1130 FIND v(dout1_17) AT=1140.05n

.meas tran vdout1_18ck1130 FIND v(dout1_18) AT=1140.05n

.meas tran vdout1_19ck1130 FIND v(dout1_19) AT=1140.05n

.meas tran vdout1_20ck1130 FIND v(dout1_20) AT=1140.05n

.meas tran vdout1_21ck1130 FIND v(dout1_21) AT=1140.05n

.meas tran vdout1_22ck1130 FIND v(dout1_22) AT=1140.05n

.meas tran vdout1_23ck1130 FIND v(dout1_23) AT=1140.05n

.meas tran vdout1_24ck1130 FIND v(dout1_24) AT=1140.05n

.meas tran vdout1_25ck1130 FIND v(dout1_25) AT=1140.05n

.meas tran vdout1_26ck1130 FIND v(dout1_26) AT=1140.05n

.meas tran vdout1_27ck1130 FIND v(dout1_27) AT=1140.05n

.meas tran vdout1_0ck1140 FIND v(dout1_0) AT=1150.05n

.meas tran vdout1_1ck1140 FIND v(dout1_1) AT=1150.05n

.meas tran vdout1_2ck1140 FIND v(dout1_2) AT=1150.05n

.meas tran vdout1_3ck1140 FIND v(dout1_3) AT=1150.05n

.meas tran vdout1_4ck1140 FIND v(dout1_4) AT=1150.05n

.meas tran vdout1_5ck1140 FIND v(dout1_5) AT=1150.05n

.meas tran vdout1_6ck1140 FIND v(dout1_6) AT=1150.05n

.meas tran vdout1_7ck1140 FIND v(dout1_7) AT=1150.05n

.meas tran vdout1_8ck1140 FIND v(dout1_8) AT=1150.05n

.meas tran vdout1_9ck1140 FIND v(dout1_9) AT=1150.05n

.meas tran vdout1_10ck1140 FIND v(dout1_10) AT=1150.05n

.meas tran vdout1_11ck1140 FIND v(dout1_11) AT=1150.05n

.meas tran vdout1_12ck1140 FIND v(dout1_12) AT=1150.05n

.meas tran vdout1_13ck1140 FIND v(dout1_13) AT=1150.05n

.meas tran vdout1_14ck1140 FIND v(dout1_14) AT=1150.05n

.meas tran vdout1_15ck1140 FIND v(dout1_15) AT=1150.05n

.meas tran vdout1_16ck1140 FIND v(dout1_16) AT=1150.05n

.meas tran vdout1_17ck1140 FIND v(dout1_17) AT=1150.05n

.meas tran vdout1_18ck1140 FIND v(dout1_18) AT=1150.05n

.meas tran vdout1_19ck1140 FIND v(dout1_19) AT=1150.05n

.meas tran vdout1_20ck1140 FIND v(dout1_20) AT=1150.05n

.meas tran vdout1_21ck1140 FIND v(dout1_21) AT=1150.05n

.meas tran vdout1_22ck1140 FIND v(dout1_22) AT=1150.05n

.meas tran vdout1_23ck1140 FIND v(dout1_23) AT=1150.05n

.meas tran vdout1_24ck1140 FIND v(dout1_24) AT=1150.05n

.meas tran vdout1_25ck1140 FIND v(dout1_25) AT=1150.05n

.meas tran vdout1_26ck1140 FIND v(dout1_26) AT=1150.05n

.meas tran vdout1_27ck1140 FIND v(dout1_27) AT=1150.05n

.meas tran vdout1_0ck1160 FIND v(dout1_0) AT=1170.05n

.meas tran vdout1_1ck1160 FIND v(dout1_1) AT=1170.05n

.meas tran vdout1_2ck1160 FIND v(dout1_2) AT=1170.05n

.meas tran vdout1_3ck1160 FIND v(dout1_3) AT=1170.05n

.meas tran vdout1_4ck1160 FIND v(dout1_4) AT=1170.05n

.meas tran vdout1_5ck1160 FIND v(dout1_5) AT=1170.05n

.meas tran vdout1_6ck1160 FIND v(dout1_6) AT=1170.05n

.meas tran vdout1_7ck1160 FIND v(dout1_7) AT=1170.05n

.meas tran vdout1_8ck1160 FIND v(dout1_8) AT=1170.05n

.meas tran vdout1_9ck1160 FIND v(dout1_9) AT=1170.05n

.meas tran vdout1_10ck1160 FIND v(dout1_10) AT=1170.05n

.meas tran vdout1_11ck1160 FIND v(dout1_11) AT=1170.05n

.meas tran vdout1_12ck1160 FIND v(dout1_12) AT=1170.05n

.meas tran vdout1_13ck1160 FIND v(dout1_13) AT=1170.05n

.meas tran vdout1_14ck1160 FIND v(dout1_14) AT=1170.05n

.meas tran vdout1_15ck1160 FIND v(dout1_15) AT=1170.05n

.meas tran vdout1_16ck1160 FIND v(dout1_16) AT=1170.05n

.meas tran vdout1_17ck1160 FIND v(dout1_17) AT=1170.05n

.meas tran vdout1_18ck1160 FIND v(dout1_18) AT=1170.05n

.meas tran vdout1_19ck1160 FIND v(dout1_19) AT=1170.05n

.meas tran vdout1_20ck1160 FIND v(dout1_20) AT=1170.05n

.meas tran vdout1_21ck1160 FIND v(dout1_21) AT=1170.05n

.meas tran vdout1_22ck1160 FIND v(dout1_22) AT=1170.05n

.meas tran vdout1_23ck1160 FIND v(dout1_23) AT=1170.05n

.meas tran vdout1_24ck1160 FIND v(dout1_24) AT=1170.05n

.meas tran vdout1_25ck1160 FIND v(dout1_25) AT=1170.05n

.meas tran vdout1_26ck1160 FIND v(dout1_26) AT=1170.05n

.meas tran vdout1_27ck1160 FIND v(dout1_27) AT=1170.05n

.meas tran vdout1_0ck1190 FIND v(dout1_0) AT=1200.05n

.meas tran vdout1_1ck1190 FIND v(dout1_1) AT=1200.05n

.meas tran vdout1_2ck1190 FIND v(dout1_2) AT=1200.05n

.meas tran vdout1_3ck1190 FIND v(dout1_3) AT=1200.05n

.meas tran vdout1_4ck1190 FIND v(dout1_4) AT=1200.05n

.meas tran vdout1_5ck1190 FIND v(dout1_5) AT=1200.05n

.meas tran vdout1_6ck1190 FIND v(dout1_6) AT=1200.05n

.meas tran vdout1_7ck1190 FIND v(dout1_7) AT=1200.05n

.meas tran vdout1_8ck1190 FIND v(dout1_8) AT=1200.05n

.meas tran vdout1_9ck1190 FIND v(dout1_9) AT=1200.05n

.meas tran vdout1_10ck1190 FIND v(dout1_10) AT=1200.05n

.meas tran vdout1_11ck1190 FIND v(dout1_11) AT=1200.05n

.meas tran vdout1_12ck1190 FIND v(dout1_12) AT=1200.05n

.meas tran vdout1_13ck1190 FIND v(dout1_13) AT=1200.05n

.meas tran vdout1_14ck1190 FIND v(dout1_14) AT=1200.05n

.meas tran vdout1_15ck1190 FIND v(dout1_15) AT=1200.05n

.meas tran vdout1_16ck1190 FIND v(dout1_16) AT=1200.05n

.meas tran vdout1_17ck1190 FIND v(dout1_17) AT=1200.05n

.meas tran vdout1_18ck1190 FIND v(dout1_18) AT=1200.05n

.meas tran vdout1_19ck1190 FIND v(dout1_19) AT=1200.05n

.meas tran vdout1_20ck1190 FIND v(dout1_20) AT=1200.05n

.meas tran vdout1_21ck1190 FIND v(dout1_21) AT=1200.05n

.meas tran vdout1_22ck1190 FIND v(dout1_22) AT=1200.05n

.meas tran vdout1_23ck1190 FIND v(dout1_23) AT=1200.05n

.meas tran vdout1_24ck1190 FIND v(dout1_24) AT=1200.05n

.meas tran vdout1_25ck1190 FIND v(dout1_25) AT=1200.05n

.meas tran vdout1_26ck1190 FIND v(dout1_26) AT=1200.05n

.meas tran vdout1_27ck1190 FIND v(dout1_27) AT=1200.05n

.meas tran vdout1_0ck1210 FIND v(dout1_0) AT=1220.05n

.meas tran vdout1_1ck1210 FIND v(dout1_1) AT=1220.05n

.meas tran vdout1_2ck1210 FIND v(dout1_2) AT=1220.05n

.meas tran vdout1_3ck1210 FIND v(dout1_3) AT=1220.05n

.meas tran vdout1_4ck1210 FIND v(dout1_4) AT=1220.05n

.meas tran vdout1_5ck1210 FIND v(dout1_5) AT=1220.05n

.meas tran vdout1_6ck1210 FIND v(dout1_6) AT=1220.05n

.meas tran vdout1_7ck1210 FIND v(dout1_7) AT=1220.05n

.meas tran vdout1_8ck1210 FIND v(dout1_8) AT=1220.05n

.meas tran vdout1_9ck1210 FIND v(dout1_9) AT=1220.05n

.meas tran vdout1_10ck1210 FIND v(dout1_10) AT=1220.05n

.meas tran vdout1_11ck1210 FIND v(dout1_11) AT=1220.05n

.meas tran vdout1_12ck1210 FIND v(dout1_12) AT=1220.05n

.meas tran vdout1_13ck1210 FIND v(dout1_13) AT=1220.05n

.meas tran vdout1_14ck1210 FIND v(dout1_14) AT=1220.05n

.meas tran vdout1_15ck1210 FIND v(dout1_15) AT=1220.05n

.meas tran vdout1_16ck1210 FIND v(dout1_16) AT=1220.05n

.meas tran vdout1_17ck1210 FIND v(dout1_17) AT=1220.05n

.meas tran vdout1_18ck1210 FIND v(dout1_18) AT=1220.05n

.meas tran vdout1_19ck1210 FIND v(dout1_19) AT=1220.05n

.meas tran vdout1_20ck1210 FIND v(dout1_20) AT=1220.05n

.meas tran vdout1_21ck1210 FIND v(dout1_21) AT=1220.05n

.meas tran vdout1_22ck1210 FIND v(dout1_22) AT=1220.05n

.meas tran vdout1_23ck1210 FIND v(dout1_23) AT=1220.05n

.meas tran vdout1_24ck1210 FIND v(dout1_24) AT=1220.05n

.meas tran vdout1_25ck1210 FIND v(dout1_25) AT=1220.05n

.meas tran vdout1_26ck1210 FIND v(dout1_26) AT=1220.05n

.meas tran vdout1_27ck1210 FIND v(dout1_27) AT=1220.05n

.meas tran vdout1_0ck1250 FIND v(dout1_0) AT=1260.05n

.meas tran vdout1_1ck1250 FIND v(dout1_1) AT=1260.05n

.meas tran vdout1_2ck1250 FIND v(dout1_2) AT=1260.05n

.meas tran vdout1_3ck1250 FIND v(dout1_3) AT=1260.05n

.meas tran vdout1_4ck1250 FIND v(dout1_4) AT=1260.05n

.meas tran vdout1_5ck1250 FIND v(dout1_5) AT=1260.05n

.meas tran vdout1_6ck1250 FIND v(dout1_6) AT=1260.05n

.meas tran vdout1_7ck1250 FIND v(dout1_7) AT=1260.05n

.meas tran vdout1_8ck1250 FIND v(dout1_8) AT=1260.05n

.meas tran vdout1_9ck1250 FIND v(dout1_9) AT=1260.05n

.meas tran vdout1_10ck1250 FIND v(dout1_10) AT=1260.05n

.meas tran vdout1_11ck1250 FIND v(dout1_11) AT=1260.05n

.meas tran vdout1_12ck1250 FIND v(dout1_12) AT=1260.05n

.meas tran vdout1_13ck1250 FIND v(dout1_13) AT=1260.05n

.meas tran vdout1_14ck1250 FIND v(dout1_14) AT=1260.05n

.meas tran vdout1_15ck1250 FIND v(dout1_15) AT=1260.05n

.meas tran vdout1_16ck1250 FIND v(dout1_16) AT=1260.05n

.meas tran vdout1_17ck1250 FIND v(dout1_17) AT=1260.05n

.meas tran vdout1_18ck1250 FIND v(dout1_18) AT=1260.05n

.meas tran vdout1_19ck1250 FIND v(dout1_19) AT=1260.05n

.meas tran vdout1_20ck1250 FIND v(dout1_20) AT=1260.05n

.meas tran vdout1_21ck1250 FIND v(dout1_21) AT=1260.05n

.meas tran vdout1_22ck1250 FIND v(dout1_22) AT=1260.05n

.meas tran vdout1_23ck1250 FIND v(dout1_23) AT=1260.05n

.meas tran vdout1_24ck1250 FIND v(dout1_24) AT=1260.05n

.meas tran vdout1_25ck1250 FIND v(dout1_25) AT=1260.05n

.meas tran vdout1_26ck1250 FIND v(dout1_26) AT=1260.05n

.meas tran vdout1_27ck1250 FIND v(dout1_27) AT=1260.05n

.meas tran vdout1_0ck1260 FIND v(dout1_0) AT=1270.05n

.meas tran vdout1_1ck1260 FIND v(dout1_1) AT=1270.05n

.meas tran vdout1_2ck1260 FIND v(dout1_2) AT=1270.05n

.meas tran vdout1_3ck1260 FIND v(dout1_3) AT=1270.05n

.meas tran vdout1_4ck1260 FIND v(dout1_4) AT=1270.05n

.meas tran vdout1_5ck1260 FIND v(dout1_5) AT=1270.05n

.meas tran vdout1_6ck1260 FIND v(dout1_6) AT=1270.05n

.meas tran vdout1_7ck1260 FIND v(dout1_7) AT=1270.05n

.meas tran vdout1_8ck1260 FIND v(dout1_8) AT=1270.05n

.meas tran vdout1_9ck1260 FIND v(dout1_9) AT=1270.05n

.meas tran vdout1_10ck1260 FIND v(dout1_10) AT=1270.05n

.meas tran vdout1_11ck1260 FIND v(dout1_11) AT=1270.05n

.meas tran vdout1_12ck1260 FIND v(dout1_12) AT=1270.05n

.meas tran vdout1_13ck1260 FIND v(dout1_13) AT=1270.05n

.meas tran vdout1_14ck1260 FIND v(dout1_14) AT=1270.05n

.meas tran vdout1_15ck1260 FIND v(dout1_15) AT=1270.05n

.meas tran vdout1_16ck1260 FIND v(dout1_16) AT=1270.05n

.meas tran vdout1_17ck1260 FIND v(dout1_17) AT=1270.05n

.meas tran vdout1_18ck1260 FIND v(dout1_18) AT=1270.05n

.meas tran vdout1_19ck1260 FIND v(dout1_19) AT=1270.05n

.meas tran vdout1_20ck1260 FIND v(dout1_20) AT=1270.05n

.meas tran vdout1_21ck1260 FIND v(dout1_21) AT=1270.05n

.meas tran vdout1_22ck1260 FIND v(dout1_22) AT=1270.05n

.meas tran vdout1_23ck1260 FIND v(dout1_23) AT=1270.05n

.meas tran vdout1_24ck1260 FIND v(dout1_24) AT=1270.05n

.meas tran vdout1_25ck1260 FIND v(dout1_25) AT=1270.05n

.meas tran vdout1_26ck1260 FIND v(dout1_26) AT=1270.05n

.meas tran vdout1_27ck1260 FIND v(dout1_27) AT=1270.05n

.meas tran vdout1_0ck1270 FIND v(dout1_0) AT=1280.05n

.meas tran vdout1_1ck1270 FIND v(dout1_1) AT=1280.05n

.meas tran vdout1_2ck1270 FIND v(dout1_2) AT=1280.05n

.meas tran vdout1_3ck1270 FIND v(dout1_3) AT=1280.05n

.meas tran vdout1_4ck1270 FIND v(dout1_4) AT=1280.05n

.meas tran vdout1_5ck1270 FIND v(dout1_5) AT=1280.05n

.meas tran vdout1_6ck1270 FIND v(dout1_6) AT=1280.05n

.meas tran vdout1_7ck1270 FIND v(dout1_7) AT=1280.05n

.meas tran vdout1_8ck1270 FIND v(dout1_8) AT=1280.05n

.meas tran vdout1_9ck1270 FIND v(dout1_9) AT=1280.05n

.meas tran vdout1_10ck1270 FIND v(dout1_10) AT=1280.05n

.meas tran vdout1_11ck1270 FIND v(dout1_11) AT=1280.05n

.meas tran vdout1_12ck1270 FIND v(dout1_12) AT=1280.05n

.meas tran vdout1_13ck1270 FIND v(dout1_13) AT=1280.05n

.meas tran vdout1_14ck1270 FIND v(dout1_14) AT=1280.05n

.meas tran vdout1_15ck1270 FIND v(dout1_15) AT=1280.05n

.meas tran vdout1_16ck1270 FIND v(dout1_16) AT=1280.05n

.meas tran vdout1_17ck1270 FIND v(dout1_17) AT=1280.05n

.meas tran vdout1_18ck1270 FIND v(dout1_18) AT=1280.05n

.meas tran vdout1_19ck1270 FIND v(dout1_19) AT=1280.05n

.meas tran vdout1_20ck1270 FIND v(dout1_20) AT=1280.05n

.meas tran vdout1_21ck1270 FIND v(dout1_21) AT=1280.05n

.meas tran vdout1_22ck1270 FIND v(dout1_22) AT=1280.05n

.meas tran vdout1_23ck1270 FIND v(dout1_23) AT=1280.05n

.meas tran vdout1_24ck1270 FIND v(dout1_24) AT=1280.05n

.meas tran vdout1_25ck1270 FIND v(dout1_25) AT=1280.05n

.meas tran vdout1_26ck1270 FIND v(dout1_26) AT=1280.05n

.meas tran vdout1_27ck1270 FIND v(dout1_27) AT=1280.05n

.meas tran vdout1_0ck1290 FIND v(dout1_0) AT=1300.05n

.meas tran vdout1_1ck1290 FIND v(dout1_1) AT=1300.05n

.meas tran vdout1_2ck1290 FIND v(dout1_2) AT=1300.05n

.meas tran vdout1_3ck1290 FIND v(dout1_3) AT=1300.05n

.meas tran vdout1_4ck1290 FIND v(dout1_4) AT=1300.05n

.meas tran vdout1_5ck1290 FIND v(dout1_5) AT=1300.05n

.meas tran vdout1_6ck1290 FIND v(dout1_6) AT=1300.05n

.meas tran vdout1_7ck1290 FIND v(dout1_7) AT=1300.05n

.meas tran vdout1_8ck1290 FIND v(dout1_8) AT=1300.05n

.meas tran vdout1_9ck1290 FIND v(dout1_9) AT=1300.05n

.meas tran vdout1_10ck1290 FIND v(dout1_10) AT=1300.05n

.meas tran vdout1_11ck1290 FIND v(dout1_11) AT=1300.05n

.meas tran vdout1_12ck1290 FIND v(dout1_12) AT=1300.05n

.meas tran vdout1_13ck1290 FIND v(dout1_13) AT=1300.05n

.meas tran vdout1_14ck1290 FIND v(dout1_14) AT=1300.05n

.meas tran vdout1_15ck1290 FIND v(dout1_15) AT=1300.05n

.meas tran vdout1_16ck1290 FIND v(dout1_16) AT=1300.05n

.meas tran vdout1_17ck1290 FIND v(dout1_17) AT=1300.05n

.meas tran vdout1_18ck1290 FIND v(dout1_18) AT=1300.05n

.meas tran vdout1_19ck1290 FIND v(dout1_19) AT=1300.05n

.meas tran vdout1_20ck1290 FIND v(dout1_20) AT=1300.05n

.meas tran vdout1_21ck1290 FIND v(dout1_21) AT=1300.05n

.meas tran vdout1_22ck1290 FIND v(dout1_22) AT=1300.05n

.meas tran vdout1_23ck1290 FIND v(dout1_23) AT=1300.05n

.meas tran vdout1_24ck1290 FIND v(dout1_24) AT=1300.05n

.meas tran vdout1_25ck1290 FIND v(dout1_25) AT=1300.05n

.meas tran vdout1_26ck1290 FIND v(dout1_26) AT=1300.05n

.meas tran vdout1_27ck1290 FIND v(dout1_27) AT=1300.05n

.meas tran vdout1_0ck1310 FIND v(dout1_0) AT=1320.05n

.meas tran vdout1_1ck1310 FIND v(dout1_1) AT=1320.05n

.meas tran vdout1_2ck1310 FIND v(dout1_2) AT=1320.05n

.meas tran vdout1_3ck1310 FIND v(dout1_3) AT=1320.05n

.meas tran vdout1_4ck1310 FIND v(dout1_4) AT=1320.05n

.meas tran vdout1_5ck1310 FIND v(dout1_5) AT=1320.05n

.meas tran vdout1_6ck1310 FIND v(dout1_6) AT=1320.05n

.meas tran vdout1_7ck1310 FIND v(dout1_7) AT=1320.05n

.meas tran vdout1_8ck1310 FIND v(dout1_8) AT=1320.05n

.meas tran vdout1_9ck1310 FIND v(dout1_9) AT=1320.05n

.meas tran vdout1_10ck1310 FIND v(dout1_10) AT=1320.05n

.meas tran vdout1_11ck1310 FIND v(dout1_11) AT=1320.05n

.meas tran vdout1_12ck1310 FIND v(dout1_12) AT=1320.05n

.meas tran vdout1_13ck1310 FIND v(dout1_13) AT=1320.05n

.meas tran vdout1_14ck1310 FIND v(dout1_14) AT=1320.05n

.meas tran vdout1_15ck1310 FIND v(dout1_15) AT=1320.05n

.meas tran vdout1_16ck1310 FIND v(dout1_16) AT=1320.05n

.meas tran vdout1_17ck1310 FIND v(dout1_17) AT=1320.05n

.meas tran vdout1_18ck1310 FIND v(dout1_18) AT=1320.05n

.meas tran vdout1_19ck1310 FIND v(dout1_19) AT=1320.05n

.meas tran vdout1_20ck1310 FIND v(dout1_20) AT=1320.05n

.meas tran vdout1_21ck1310 FIND v(dout1_21) AT=1320.05n

.meas tran vdout1_22ck1310 FIND v(dout1_22) AT=1320.05n

.meas tran vdout1_23ck1310 FIND v(dout1_23) AT=1320.05n

.meas tran vdout1_24ck1310 FIND v(dout1_24) AT=1320.05n

.meas tran vdout1_25ck1310 FIND v(dout1_25) AT=1320.05n

.meas tran vdout1_26ck1310 FIND v(dout1_26) AT=1320.05n

.meas tran vdout1_27ck1310 FIND v(dout1_27) AT=1320.05n

.meas tran vdout1_0ck1320 FIND v(dout1_0) AT=1330.05n

.meas tran vdout1_1ck1320 FIND v(dout1_1) AT=1330.05n

.meas tran vdout1_2ck1320 FIND v(dout1_2) AT=1330.05n

.meas tran vdout1_3ck1320 FIND v(dout1_3) AT=1330.05n

.meas tran vdout1_4ck1320 FIND v(dout1_4) AT=1330.05n

.meas tran vdout1_5ck1320 FIND v(dout1_5) AT=1330.05n

.meas tran vdout1_6ck1320 FIND v(dout1_6) AT=1330.05n

.meas tran vdout1_7ck1320 FIND v(dout1_7) AT=1330.05n

.meas tran vdout1_8ck1320 FIND v(dout1_8) AT=1330.05n

.meas tran vdout1_9ck1320 FIND v(dout1_9) AT=1330.05n

.meas tran vdout1_10ck1320 FIND v(dout1_10) AT=1330.05n

.meas tran vdout1_11ck1320 FIND v(dout1_11) AT=1330.05n

.meas tran vdout1_12ck1320 FIND v(dout1_12) AT=1330.05n

.meas tran vdout1_13ck1320 FIND v(dout1_13) AT=1330.05n

.meas tran vdout1_14ck1320 FIND v(dout1_14) AT=1330.05n

.meas tran vdout1_15ck1320 FIND v(dout1_15) AT=1330.05n

.meas tran vdout1_16ck1320 FIND v(dout1_16) AT=1330.05n

.meas tran vdout1_17ck1320 FIND v(dout1_17) AT=1330.05n

.meas tran vdout1_18ck1320 FIND v(dout1_18) AT=1330.05n

.meas tran vdout1_19ck1320 FIND v(dout1_19) AT=1330.05n

.meas tran vdout1_20ck1320 FIND v(dout1_20) AT=1330.05n

.meas tran vdout1_21ck1320 FIND v(dout1_21) AT=1330.05n

.meas tran vdout1_22ck1320 FIND v(dout1_22) AT=1330.05n

.meas tran vdout1_23ck1320 FIND v(dout1_23) AT=1330.05n

.meas tran vdout1_24ck1320 FIND v(dout1_24) AT=1330.05n

.meas tran vdout1_25ck1320 FIND v(dout1_25) AT=1330.05n

.meas tran vdout1_26ck1320 FIND v(dout1_26) AT=1330.05n

.meas tran vdout1_27ck1320 FIND v(dout1_27) AT=1330.05n

.meas tran vdout1_0ck1350 FIND v(dout1_0) AT=1360.05n

.meas tran vdout1_1ck1350 FIND v(dout1_1) AT=1360.05n

.meas tran vdout1_2ck1350 FIND v(dout1_2) AT=1360.05n

.meas tran vdout1_3ck1350 FIND v(dout1_3) AT=1360.05n

.meas tran vdout1_4ck1350 FIND v(dout1_4) AT=1360.05n

.meas tran vdout1_5ck1350 FIND v(dout1_5) AT=1360.05n

.meas tran vdout1_6ck1350 FIND v(dout1_6) AT=1360.05n

.meas tran vdout1_7ck1350 FIND v(dout1_7) AT=1360.05n

.meas tran vdout1_8ck1350 FIND v(dout1_8) AT=1360.05n

.meas tran vdout1_9ck1350 FIND v(dout1_9) AT=1360.05n

.meas tran vdout1_10ck1350 FIND v(dout1_10) AT=1360.05n

.meas tran vdout1_11ck1350 FIND v(dout1_11) AT=1360.05n

.meas tran vdout1_12ck1350 FIND v(dout1_12) AT=1360.05n

.meas tran vdout1_13ck1350 FIND v(dout1_13) AT=1360.05n

.meas tran vdout1_14ck1350 FIND v(dout1_14) AT=1360.05n

.meas tran vdout1_15ck1350 FIND v(dout1_15) AT=1360.05n

.meas tran vdout1_16ck1350 FIND v(dout1_16) AT=1360.05n

.meas tran vdout1_17ck1350 FIND v(dout1_17) AT=1360.05n

.meas tran vdout1_18ck1350 FIND v(dout1_18) AT=1360.05n

.meas tran vdout1_19ck1350 FIND v(dout1_19) AT=1360.05n

.meas tran vdout1_20ck1350 FIND v(dout1_20) AT=1360.05n

.meas tran vdout1_21ck1350 FIND v(dout1_21) AT=1360.05n

.meas tran vdout1_22ck1350 FIND v(dout1_22) AT=1360.05n

.meas tran vdout1_23ck1350 FIND v(dout1_23) AT=1360.05n

.meas tran vdout1_24ck1350 FIND v(dout1_24) AT=1360.05n

.meas tran vdout1_25ck1350 FIND v(dout1_25) AT=1360.05n

.meas tran vdout1_26ck1350 FIND v(dout1_26) AT=1360.05n

.meas tran vdout1_27ck1350 FIND v(dout1_27) AT=1360.05n

.meas tran vdout1_0ck1410 FIND v(dout1_0) AT=1420.05n

.meas tran vdout1_1ck1410 FIND v(dout1_1) AT=1420.05n

.meas tran vdout1_2ck1410 FIND v(dout1_2) AT=1420.05n

.meas tran vdout1_3ck1410 FIND v(dout1_3) AT=1420.05n

.meas tran vdout1_4ck1410 FIND v(dout1_4) AT=1420.05n

.meas tran vdout1_5ck1410 FIND v(dout1_5) AT=1420.05n

.meas tran vdout1_6ck1410 FIND v(dout1_6) AT=1420.05n

.meas tran vdout1_7ck1410 FIND v(dout1_7) AT=1420.05n

.meas tran vdout1_8ck1410 FIND v(dout1_8) AT=1420.05n

.meas tran vdout1_9ck1410 FIND v(dout1_9) AT=1420.05n

.meas tran vdout1_10ck1410 FIND v(dout1_10) AT=1420.05n

.meas tran vdout1_11ck1410 FIND v(dout1_11) AT=1420.05n

.meas tran vdout1_12ck1410 FIND v(dout1_12) AT=1420.05n

.meas tran vdout1_13ck1410 FIND v(dout1_13) AT=1420.05n

.meas tran vdout1_14ck1410 FIND v(dout1_14) AT=1420.05n

.meas tran vdout1_15ck1410 FIND v(dout1_15) AT=1420.05n

.meas tran vdout1_16ck1410 FIND v(dout1_16) AT=1420.05n

.meas tran vdout1_17ck1410 FIND v(dout1_17) AT=1420.05n

.meas tran vdout1_18ck1410 FIND v(dout1_18) AT=1420.05n

.meas tran vdout1_19ck1410 FIND v(dout1_19) AT=1420.05n

.meas tran vdout1_20ck1410 FIND v(dout1_20) AT=1420.05n

.meas tran vdout1_21ck1410 FIND v(dout1_21) AT=1420.05n

.meas tran vdout1_22ck1410 FIND v(dout1_22) AT=1420.05n

.meas tran vdout1_23ck1410 FIND v(dout1_23) AT=1420.05n

.meas tran vdout1_24ck1410 FIND v(dout1_24) AT=1420.05n

.meas tran vdout1_25ck1410 FIND v(dout1_25) AT=1420.05n

.meas tran vdout1_26ck1410 FIND v(dout1_26) AT=1420.05n

.meas tran vdout1_27ck1410 FIND v(dout1_27) AT=1420.05n

.meas tran vdout1_0ck1430 FIND v(dout1_0) AT=1440.05n

.meas tran vdout1_1ck1430 FIND v(dout1_1) AT=1440.05n

.meas tran vdout1_2ck1430 FIND v(dout1_2) AT=1440.05n

.meas tran vdout1_3ck1430 FIND v(dout1_3) AT=1440.05n

.meas tran vdout1_4ck1430 FIND v(dout1_4) AT=1440.05n

.meas tran vdout1_5ck1430 FIND v(dout1_5) AT=1440.05n

.meas tran vdout1_6ck1430 FIND v(dout1_6) AT=1440.05n

.meas tran vdout1_7ck1430 FIND v(dout1_7) AT=1440.05n

.meas tran vdout1_8ck1430 FIND v(dout1_8) AT=1440.05n

.meas tran vdout1_9ck1430 FIND v(dout1_9) AT=1440.05n

.meas tran vdout1_10ck1430 FIND v(dout1_10) AT=1440.05n

.meas tran vdout1_11ck1430 FIND v(dout1_11) AT=1440.05n

.meas tran vdout1_12ck1430 FIND v(dout1_12) AT=1440.05n

.meas tran vdout1_13ck1430 FIND v(dout1_13) AT=1440.05n

.meas tran vdout1_14ck1430 FIND v(dout1_14) AT=1440.05n

.meas tran vdout1_15ck1430 FIND v(dout1_15) AT=1440.05n

.meas tran vdout1_16ck1430 FIND v(dout1_16) AT=1440.05n

.meas tran vdout1_17ck1430 FIND v(dout1_17) AT=1440.05n

.meas tran vdout1_18ck1430 FIND v(dout1_18) AT=1440.05n

.meas tran vdout1_19ck1430 FIND v(dout1_19) AT=1440.05n

.meas tran vdout1_20ck1430 FIND v(dout1_20) AT=1440.05n

.meas tran vdout1_21ck1430 FIND v(dout1_21) AT=1440.05n

.meas tran vdout1_22ck1430 FIND v(dout1_22) AT=1440.05n

.meas tran vdout1_23ck1430 FIND v(dout1_23) AT=1440.05n

.meas tran vdout1_24ck1430 FIND v(dout1_24) AT=1440.05n

.meas tran vdout1_25ck1430 FIND v(dout1_25) AT=1440.05n

.meas tran vdout1_26ck1430 FIND v(dout1_26) AT=1440.05n

.meas tran vdout1_27ck1430 FIND v(dout1_27) AT=1440.05n

.meas tran vdout1_0ck1500 FIND v(dout1_0) AT=1510.05n

.meas tran vdout1_1ck1500 FIND v(dout1_1) AT=1510.05n

.meas tran vdout1_2ck1500 FIND v(dout1_2) AT=1510.05n

.meas tran vdout1_3ck1500 FIND v(dout1_3) AT=1510.05n

.meas tran vdout1_4ck1500 FIND v(dout1_4) AT=1510.05n

.meas tran vdout1_5ck1500 FIND v(dout1_5) AT=1510.05n

.meas tran vdout1_6ck1500 FIND v(dout1_6) AT=1510.05n

.meas tran vdout1_7ck1500 FIND v(dout1_7) AT=1510.05n

.meas tran vdout1_8ck1500 FIND v(dout1_8) AT=1510.05n

.meas tran vdout1_9ck1500 FIND v(dout1_9) AT=1510.05n

.meas tran vdout1_10ck1500 FIND v(dout1_10) AT=1510.05n

.meas tran vdout1_11ck1500 FIND v(dout1_11) AT=1510.05n

.meas tran vdout1_12ck1500 FIND v(dout1_12) AT=1510.05n

.meas tran vdout1_13ck1500 FIND v(dout1_13) AT=1510.05n

.meas tran vdout1_14ck1500 FIND v(dout1_14) AT=1510.05n

.meas tran vdout1_15ck1500 FIND v(dout1_15) AT=1510.05n

.meas tran vdout1_16ck1500 FIND v(dout1_16) AT=1510.05n

.meas tran vdout1_17ck1500 FIND v(dout1_17) AT=1510.05n

.meas tran vdout1_18ck1500 FIND v(dout1_18) AT=1510.05n

.meas tran vdout1_19ck1500 FIND v(dout1_19) AT=1510.05n

.meas tran vdout1_20ck1500 FIND v(dout1_20) AT=1510.05n

.meas tran vdout1_21ck1500 FIND v(dout1_21) AT=1510.05n

.meas tran vdout1_22ck1500 FIND v(dout1_22) AT=1510.05n

.meas tran vdout1_23ck1500 FIND v(dout1_23) AT=1510.05n

.meas tran vdout1_24ck1500 FIND v(dout1_24) AT=1510.05n

.meas tran vdout1_25ck1500 FIND v(dout1_25) AT=1510.05n

.meas tran vdout1_26ck1500 FIND v(dout1_26) AT=1510.05n

.meas tran vdout1_27ck1500 FIND v(dout1_27) AT=1510.05n

.meas tran vdout1_0ck1570 FIND v(dout1_0) AT=1580.05n

.meas tran vdout1_1ck1570 FIND v(dout1_1) AT=1580.05n

.meas tran vdout1_2ck1570 FIND v(dout1_2) AT=1580.05n

.meas tran vdout1_3ck1570 FIND v(dout1_3) AT=1580.05n

.meas tran vdout1_4ck1570 FIND v(dout1_4) AT=1580.05n

.meas tran vdout1_5ck1570 FIND v(dout1_5) AT=1580.05n

.meas tran vdout1_6ck1570 FIND v(dout1_6) AT=1580.05n

.meas tran vdout1_7ck1570 FIND v(dout1_7) AT=1580.05n

.meas tran vdout1_8ck1570 FIND v(dout1_8) AT=1580.05n

.meas tran vdout1_9ck1570 FIND v(dout1_9) AT=1580.05n

.meas tran vdout1_10ck1570 FIND v(dout1_10) AT=1580.05n

.meas tran vdout1_11ck1570 FIND v(dout1_11) AT=1580.05n

.meas tran vdout1_12ck1570 FIND v(dout1_12) AT=1580.05n

.meas tran vdout1_13ck1570 FIND v(dout1_13) AT=1580.05n

.meas tran vdout1_14ck1570 FIND v(dout1_14) AT=1580.05n

.meas tran vdout1_15ck1570 FIND v(dout1_15) AT=1580.05n

.meas tran vdout1_16ck1570 FIND v(dout1_16) AT=1580.05n

.meas tran vdout1_17ck1570 FIND v(dout1_17) AT=1580.05n

.meas tran vdout1_18ck1570 FIND v(dout1_18) AT=1580.05n

.meas tran vdout1_19ck1570 FIND v(dout1_19) AT=1580.05n

.meas tran vdout1_20ck1570 FIND v(dout1_20) AT=1580.05n

.meas tran vdout1_21ck1570 FIND v(dout1_21) AT=1580.05n

.meas tran vdout1_22ck1570 FIND v(dout1_22) AT=1580.05n

.meas tran vdout1_23ck1570 FIND v(dout1_23) AT=1580.05n

.meas tran vdout1_24ck1570 FIND v(dout1_24) AT=1580.05n

.meas tran vdout1_25ck1570 FIND v(dout1_25) AT=1580.05n

.meas tran vdout1_26ck1570 FIND v(dout1_26) AT=1580.05n

.meas tran vdout1_27ck1570 FIND v(dout1_27) AT=1580.05n

.meas tran vdout1_0ck1600 FIND v(dout1_0) AT=1610.05n

.meas tran vdout1_1ck1600 FIND v(dout1_1) AT=1610.05n

.meas tran vdout1_2ck1600 FIND v(dout1_2) AT=1610.05n

.meas tran vdout1_3ck1600 FIND v(dout1_3) AT=1610.05n

.meas tran vdout1_4ck1600 FIND v(dout1_4) AT=1610.05n

.meas tran vdout1_5ck1600 FIND v(dout1_5) AT=1610.05n

.meas tran vdout1_6ck1600 FIND v(dout1_6) AT=1610.05n

.meas tran vdout1_7ck1600 FIND v(dout1_7) AT=1610.05n

.meas tran vdout1_8ck1600 FIND v(dout1_8) AT=1610.05n

.meas tran vdout1_9ck1600 FIND v(dout1_9) AT=1610.05n

.meas tran vdout1_10ck1600 FIND v(dout1_10) AT=1610.05n

.meas tran vdout1_11ck1600 FIND v(dout1_11) AT=1610.05n

.meas tran vdout1_12ck1600 FIND v(dout1_12) AT=1610.05n

.meas tran vdout1_13ck1600 FIND v(dout1_13) AT=1610.05n

.meas tran vdout1_14ck1600 FIND v(dout1_14) AT=1610.05n

.meas tran vdout1_15ck1600 FIND v(dout1_15) AT=1610.05n

.meas tran vdout1_16ck1600 FIND v(dout1_16) AT=1610.05n

.meas tran vdout1_17ck1600 FIND v(dout1_17) AT=1610.05n

.meas tran vdout1_18ck1600 FIND v(dout1_18) AT=1610.05n

.meas tran vdout1_19ck1600 FIND v(dout1_19) AT=1610.05n

.meas tran vdout1_20ck1600 FIND v(dout1_20) AT=1610.05n

.meas tran vdout1_21ck1600 FIND v(dout1_21) AT=1610.05n

.meas tran vdout1_22ck1600 FIND v(dout1_22) AT=1610.05n

.meas tran vdout1_23ck1600 FIND v(dout1_23) AT=1610.05n

.meas tran vdout1_24ck1600 FIND v(dout1_24) AT=1610.05n

.meas tran vdout1_25ck1600 FIND v(dout1_25) AT=1610.05n

.meas tran vdout1_26ck1600 FIND v(dout1_26) AT=1610.05n

.meas tran vdout1_27ck1600 FIND v(dout1_27) AT=1610.05n

.meas tran vdout1_0ck1640 FIND v(dout1_0) AT=1650.05n

.meas tran vdout1_1ck1640 FIND v(dout1_1) AT=1650.05n

.meas tran vdout1_2ck1640 FIND v(dout1_2) AT=1650.05n

.meas tran vdout1_3ck1640 FIND v(dout1_3) AT=1650.05n

.meas tran vdout1_4ck1640 FIND v(dout1_4) AT=1650.05n

.meas tran vdout1_5ck1640 FIND v(dout1_5) AT=1650.05n

.meas tran vdout1_6ck1640 FIND v(dout1_6) AT=1650.05n

.meas tran vdout1_7ck1640 FIND v(dout1_7) AT=1650.05n

.meas tran vdout1_8ck1640 FIND v(dout1_8) AT=1650.05n

.meas tran vdout1_9ck1640 FIND v(dout1_9) AT=1650.05n

.meas tran vdout1_10ck1640 FIND v(dout1_10) AT=1650.05n

.meas tran vdout1_11ck1640 FIND v(dout1_11) AT=1650.05n

.meas tran vdout1_12ck1640 FIND v(dout1_12) AT=1650.05n

.meas tran vdout1_13ck1640 FIND v(dout1_13) AT=1650.05n

.meas tran vdout1_14ck1640 FIND v(dout1_14) AT=1650.05n

.meas tran vdout1_15ck1640 FIND v(dout1_15) AT=1650.05n

.meas tran vdout1_16ck1640 FIND v(dout1_16) AT=1650.05n

.meas tran vdout1_17ck1640 FIND v(dout1_17) AT=1650.05n

.meas tran vdout1_18ck1640 FIND v(dout1_18) AT=1650.05n

.meas tran vdout1_19ck1640 FIND v(dout1_19) AT=1650.05n

.meas tran vdout1_20ck1640 FIND v(dout1_20) AT=1650.05n

.meas tran vdout1_21ck1640 FIND v(dout1_21) AT=1650.05n

.meas tran vdout1_22ck1640 FIND v(dout1_22) AT=1650.05n

.meas tran vdout1_23ck1640 FIND v(dout1_23) AT=1650.05n

.meas tran vdout1_24ck1640 FIND v(dout1_24) AT=1650.05n

.meas tran vdout1_25ck1640 FIND v(dout1_25) AT=1650.05n

.meas tran vdout1_26ck1640 FIND v(dout1_26) AT=1650.05n

.meas tran vdout1_27ck1640 FIND v(dout1_27) AT=1650.05n

.meas tran vdout1_0ck1650 FIND v(dout1_0) AT=1660.05n

.meas tran vdout1_1ck1650 FIND v(dout1_1) AT=1660.05n

.meas tran vdout1_2ck1650 FIND v(dout1_2) AT=1660.05n

.meas tran vdout1_3ck1650 FIND v(dout1_3) AT=1660.05n

.meas tran vdout1_4ck1650 FIND v(dout1_4) AT=1660.05n

.meas tran vdout1_5ck1650 FIND v(dout1_5) AT=1660.05n

.meas tran vdout1_6ck1650 FIND v(dout1_6) AT=1660.05n

.meas tran vdout1_7ck1650 FIND v(dout1_7) AT=1660.05n

.meas tran vdout1_8ck1650 FIND v(dout1_8) AT=1660.05n

.meas tran vdout1_9ck1650 FIND v(dout1_9) AT=1660.05n

.meas tran vdout1_10ck1650 FIND v(dout1_10) AT=1660.05n

.meas tran vdout1_11ck1650 FIND v(dout1_11) AT=1660.05n

.meas tran vdout1_12ck1650 FIND v(dout1_12) AT=1660.05n

.meas tran vdout1_13ck1650 FIND v(dout1_13) AT=1660.05n

.meas tran vdout1_14ck1650 FIND v(dout1_14) AT=1660.05n

.meas tran vdout1_15ck1650 FIND v(dout1_15) AT=1660.05n

.meas tran vdout1_16ck1650 FIND v(dout1_16) AT=1660.05n

.meas tran vdout1_17ck1650 FIND v(dout1_17) AT=1660.05n

.meas tran vdout1_18ck1650 FIND v(dout1_18) AT=1660.05n

.meas tran vdout1_19ck1650 FIND v(dout1_19) AT=1660.05n

.meas tran vdout1_20ck1650 FIND v(dout1_20) AT=1660.05n

.meas tran vdout1_21ck1650 FIND v(dout1_21) AT=1660.05n

.meas tran vdout1_22ck1650 FIND v(dout1_22) AT=1660.05n

.meas tran vdout1_23ck1650 FIND v(dout1_23) AT=1660.05n

.meas tran vdout1_24ck1650 FIND v(dout1_24) AT=1660.05n

.meas tran vdout1_25ck1650 FIND v(dout1_25) AT=1660.05n

.meas tran vdout1_26ck1650 FIND v(dout1_26) AT=1660.05n

.meas tran vdout1_27ck1650 FIND v(dout1_27) AT=1660.05n

.meas tran vdout1_0ck1680 FIND v(dout1_0) AT=1690.05n

.meas tran vdout1_1ck1680 FIND v(dout1_1) AT=1690.05n

.meas tran vdout1_2ck1680 FIND v(dout1_2) AT=1690.05n

.meas tran vdout1_3ck1680 FIND v(dout1_3) AT=1690.05n

.meas tran vdout1_4ck1680 FIND v(dout1_4) AT=1690.05n

.meas tran vdout1_5ck1680 FIND v(dout1_5) AT=1690.05n

.meas tran vdout1_6ck1680 FIND v(dout1_6) AT=1690.05n

.meas tran vdout1_7ck1680 FIND v(dout1_7) AT=1690.05n

.meas tran vdout1_8ck1680 FIND v(dout1_8) AT=1690.05n

.meas tran vdout1_9ck1680 FIND v(dout1_9) AT=1690.05n

.meas tran vdout1_10ck1680 FIND v(dout1_10) AT=1690.05n

.meas tran vdout1_11ck1680 FIND v(dout1_11) AT=1690.05n

.meas tran vdout1_12ck1680 FIND v(dout1_12) AT=1690.05n

.meas tran vdout1_13ck1680 FIND v(dout1_13) AT=1690.05n

.meas tran vdout1_14ck1680 FIND v(dout1_14) AT=1690.05n

.meas tran vdout1_15ck1680 FIND v(dout1_15) AT=1690.05n

.meas tran vdout1_16ck1680 FIND v(dout1_16) AT=1690.05n

.meas tran vdout1_17ck1680 FIND v(dout1_17) AT=1690.05n

.meas tran vdout1_18ck1680 FIND v(dout1_18) AT=1690.05n

.meas tran vdout1_19ck1680 FIND v(dout1_19) AT=1690.05n

.meas tran vdout1_20ck1680 FIND v(dout1_20) AT=1690.05n

.meas tran vdout1_21ck1680 FIND v(dout1_21) AT=1690.05n

.meas tran vdout1_22ck1680 FIND v(dout1_22) AT=1690.05n

.meas tran vdout1_23ck1680 FIND v(dout1_23) AT=1690.05n

.meas tran vdout1_24ck1680 FIND v(dout1_24) AT=1690.05n

.meas tran vdout1_25ck1680 FIND v(dout1_25) AT=1690.05n

.meas tran vdout1_26ck1680 FIND v(dout1_26) AT=1690.05n

.meas tran vdout1_27ck1680 FIND v(dout1_27) AT=1690.05n

.meas tran vdout1_0ck1700 FIND v(dout1_0) AT=1710.05n

.meas tran vdout1_1ck1700 FIND v(dout1_1) AT=1710.05n

.meas tran vdout1_2ck1700 FIND v(dout1_2) AT=1710.05n

.meas tran vdout1_3ck1700 FIND v(dout1_3) AT=1710.05n

.meas tran vdout1_4ck1700 FIND v(dout1_4) AT=1710.05n

.meas tran vdout1_5ck1700 FIND v(dout1_5) AT=1710.05n

.meas tran vdout1_6ck1700 FIND v(dout1_6) AT=1710.05n

.meas tran vdout1_7ck1700 FIND v(dout1_7) AT=1710.05n

.meas tran vdout1_8ck1700 FIND v(dout1_8) AT=1710.05n

.meas tran vdout1_9ck1700 FIND v(dout1_9) AT=1710.05n

.meas tran vdout1_10ck1700 FIND v(dout1_10) AT=1710.05n

.meas tran vdout1_11ck1700 FIND v(dout1_11) AT=1710.05n

.meas tran vdout1_12ck1700 FIND v(dout1_12) AT=1710.05n

.meas tran vdout1_13ck1700 FIND v(dout1_13) AT=1710.05n

.meas tran vdout1_14ck1700 FIND v(dout1_14) AT=1710.05n

.meas tran vdout1_15ck1700 FIND v(dout1_15) AT=1710.05n

.meas tran vdout1_16ck1700 FIND v(dout1_16) AT=1710.05n

.meas tran vdout1_17ck1700 FIND v(dout1_17) AT=1710.05n

.meas tran vdout1_18ck1700 FIND v(dout1_18) AT=1710.05n

.meas tran vdout1_19ck1700 FIND v(dout1_19) AT=1710.05n

.meas tran vdout1_20ck1700 FIND v(dout1_20) AT=1710.05n

.meas tran vdout1_21ck1700 FIND v(dout1_21) AT=1710.05n

.meas tran vdout1_22ck1700 FIND v(dout1_22) AT=1710.05n

.meas tran vdout1_23ck1700 FIND v(dout1_23) AT=1710.05n

.meas tran vdout1_24ck1700 FIND v(dout1_24) AT=1710.05n

.meas tran vdout1_25ck1700 FIND v(dout1_25) AT=1710.05n

.meas tran vdout1_26ck1700 FIND v(dout1_26) AT=1710.05n

.meas tran vdout1_27ck1700 FIND v(dout1_27) AT=1710.05n

.meas tran vdout1_0ck1730 FIND v(dout1_0) AT=1740.05n

.meas tran vdout1_1ck1730 FIND v(dout1_1) AT=1740.05n

.meas tran vdout1_2ck1730 FIND v(dout1_2) AT=1740.05n

.meas tran vdout1_3ck1730 FIND v(dout1_3) AT=1740.05n

.meas tran vdout1_4ck1730 FIND v(dout1_4) AT=1740.05n

.meas tran vdout1_5ck1730 FIND v(dout1_5) AT=1740.05n

.meas tran vdout1_6ck1730 FIND v(dout1_6) AT=1740.05n

.meas tran vdout1_7ck1730 FIND v(dout1_7) AT=1740.05n

.meas tran vdout1_8ck1730 FIND v(dout1_8) AT=1740.05n

.meas tran vdout1_9ck1730 FIND v(dout1_9) AT=1740.05n

.meas tran vdout1_10ck1730 FIND v(dout1_10) AT=1740.05n

.meas tran vdout1_11ck1730 FIND v(dout1_11) AT=1740.05n

.meas tran vdout1_12ck1730 FIND v(dout1_12) AT=1740.05n

.meas tran vdout1_13ck1730 FIND v(dout1_13) AT=1740.05n

.meas tran vdout1_14ck1730 FIND v(dout1_14) AT=1740.05n

.meas tran vdout1_15ck1730 FIND v(dout1_15) AT=1740.05n

.meas tran vdout1_16ck1730 FIND v(dout1_16) AT=1740.05n

.meas tran vdout1_17ck1730 FIND v(dout1_17) AT=1740.05n

.meas tran vdout1_18ck1730 FIND v(dout1_18) AT=1740.05n

.meas tran vdout1_19ck1730 FIND v(dout1_19) AT=1740.05n

.meas tran vdout1_20ck1730 FIND v(dout1_20) AT=1740.05n

.meas tran vdout1_21ck1730 FIND v(dout1_21) AT=1740.05n

.meas tran vdout1_22ck1730 FIND v(dout1_22) AT=1740.05n

.meas tran vdout1_23ck1730 FIND v(dout1_23) AT=1740.05n

.meas tran vdout1_24ck1730 FIND v(dout1_24) AT=1740.05n

.meas tran vdout1_25ck1730 FIND v(dout1_25) AT=1740.05n

.meas tran vdout1_26ck1730 FIND v(dout1_26) AT=1740.05n

.meas tran vdout1_27ck1730 FIND v(dout1_27) AT=1740.05n

.meas tran vdout1_0ck1760 FIND v(dout1_0) AT=1770.05n

.meas tran vdout1_1ck1760 FIND v(dout1_1) AT=1770.05n

.meas tran vdout1_2ck1760 FIND v(dout1_2) AT=1770.05n

.meas tran vdout1_3ck1760 FIND v(dout1_3) AT=1770.05n

.meas tran vdout1_4ck1760 FIND v(dout1_4) AT=1770.05n

.meas tran vdout1_5ck1760 FIND v(dout1_5) AT=1770.05n

.meas tran vdout1_6ck1760 FIND v(dout1_6) AT=1770.05n

.meas tran vdout1_7ck1760 FIND v(dout1_7) AT=1770.05n

.meas tran vdout1_8ck1760 FIND v(dout1_8) AT=1770.05n

.meas tran vdout1_9ck1760 FIND v(dout1_9) AT=1770.05n

.meas tran vdout1_10ck1760 FIND v(dout1_10) AT=1770.05n

.meas tran vdout1_11ck1760 FIND v(dout1_11) AT=1770.05n

.meas tran vdout1_12ck1760 FIND v(dout1_12) AT=1770.05n

.meas tran vdout1_13ck1760 FIND v(dout1_13) AT=1770.05n

.meas tran vdout1_14ck1760 FIND v(dout1_14) AT=1770.05n

.meas tran vdout1_15ck1760 FIND v(dout1_15) AT=1770.05n

.meas tran vdout1_16ck1760 FIND v(dout1_16) AT=1770.05n

.meas tran vdout1_17ck1760 FIND v(dout1_17) AT=1770.05n

.meas tran vdout1_18ck1760 FIND v(dout1_18) AT=1770.05n

.meas tran vdout1_19ck1760 FIND v(dout1_19) AT=1770.05n

.meas tran vdout1_20ck1760 FIND v(dout1_20) AT=1770.05n

.meas tran vdout1_21ck1760 FIND v(dout1_21) AT=1770.05n

.meas tran vdout1_22ck1760 FIND v(dout1_22) AT=1770.05n

.meas tran vdout1_23ck1760 FIND v(dout1_23) AT=1770.05n

.meas tran vdout1_24ck1760 FIND v(dout1_24) AT=1770.05n

.meas tran vdout1_25ck1760 FIND v(dout1_25) AT=1770.05n

.meas tran vdout1_26ck1760 FIND v(dout1_26) AT=1770.05n

.meas tran vdout1_27ck1760 FIND v(dout1_27) AT=1770.05n

.meas tran vdout1_0ck1770 FIND v(dout1_0) AT=1780.05n

.meas tran vdout1_1ck1770 FIND v(dout1_1) AT=1780.05n

.meas tran vdout1_2ck1770 FIND v(dout1_2) AT=1780.05n

.meas tran vdout1_3ck1770 FIND v(dout1_3) AT=1780.05n

.meas tran vdout1_4ck1770 FIND v(dout1_4) AT=1780.05n

.meas tran vdout1_5ck1770 FIND v(dout1_5) AT=1780.05n

.meas tran vdout1_6ck1770 FIND v(dout1_6) AT=1780.05n

.meas tran vdout1_7ck1770 FIND v(dout1_7) AT=1780.05n

.meas tran vdout1_8ck1770 FIND v(dout1_8) AT=1780.05n

.meas tran vdout1_9ck1770 FIND v(dout1_9) AT=1780.05n

.meas tran vdout1_10ck1770 FIND v(dout1_10) AT=1780.05n

.meas tran vdout1_11ck1770 FIND v(dout1_11) AT=1780.05n

.meas tran vdout1_12ck1770 FIND v(dout1_12) AT=1780.05n

.meas tran vdout1_13ck1770 FIND v(dout1_13) AT=1780.05n

.meas tran vdout1_14ck1770 FIND v(dout1_14) AT=1780.05n

.meas tran vdout1_15ck1770 FIND v(dout1_15) AT=1780.05n

.meas tran vdout1_16ck1770 FIND v(dout1_16) AT=1780.05n

.meas tran vdout1_17ck1770 FIND v(dout1_17) AT=1780.05n

.meas tran vdout1_18ck1770 FIND v(dout1_18) AT=1780.05n

.meas tran vdout1_19ck1770 FIND v(dout1_19) AT=1780.05n

.meas tran vdout1_20ck1770 FIND v(dout1_20) AT=1780.05n

.meas tran vdout1_21ck1770 FIND v(dout1_21) AT=1780.05n

.meas tran vdout1_22ck1770 FIND v(dout1_22) AT=1780.05n

.meas tran vdout1_23ck1770 FIND v(dout1_23) AT=1780.05n

.meas tran vdout1_24ck1770 FIND v(dout1_24) AT=1780.05n

.meas tran vdout1_25ck1770 FIND v(dout1_25) AT=1780.05n

.meas tran vdout1_26ck1770 FIND v(dout1_26) AT=1780.05n

.meas tran vdout1_27ck1770 FIND v(dout1_27) AT=1780.05n

.meas tran vdout1_0ck1790 FIND v(dout1_0) AT=1800.05n

.meas tran vdout1_1ck1790 FIND v(dout1_1) AT=1800.05n

.meas tran vdout1_2ck1790 FIND v(dout1_2) AT=1800.05n

.meas tran vdout1_3ck1790 FIND v(dout1_3) AT=1800.05n

.meas tran vdout1_4ck1790 FIND v(dout1_4) AT=1800.05n

.meas tran vdout1_5ck1790 FIND v(dout1_5) AT=1800.05n

.meas tran vdout1_6ck1790 FIND v(dout1_6) AT=1800.05n

.meas tran vdout1_7ck1790 FIND v(dout1_7) AT=1800.05n

.meas tran vdout1_8ck1790 FIND v(dout1_8) AT=1800.05n

.meas tran vdout1_9ck1790 FIND v(dout1_9) AT=1800.05n

.meas tran vdout1_10ck1790 FIND v(dout1_10) AT=1800.05n

.meas tran vdout1_11ck1790 FIND v(dout1_11) AT=1800.05n

.meas tran vdout1_12ck1790 FIND v(dout1_12) AT=1800.05n

.meas tran vdout1_13ck1790 FIND v(dout1_13) AT=1800.05n

.meas tran vdout1_14ck1790 FIND v(dout1_14) AT=1800.05n

.meas tran vdout1_15ck1790 FIND v(dout1_15) AT=1800.05n

.meas tran vdout1_16ck1790 FIND v(dout1_16) AT=1800.05n

.meas tran vdout1_17ck1790 FIND v(dout1_17) AT=1800.05n

.meas tran vdout1_18ck1790 FIND v(dout1_18) AT=1800.05n

.meas tran vdout1_19ck1790 FIND v(dout1_19) AT=1800.05n

.meas tran vdout1_20ck1790 FIND v(dout1_20) AT=1800.05n

.meas tran vdout1_21ck1790 FIND v(dout1_21) AT=1800.05n

.meas tran vdout1_22ck1790 FIND v(dout1_22) AT=1800.05n

.meas tran vdout1_23ck1790 FIND v(dout1_23) AT=1800.05n

.meas tran vdout1_24ck1790 FIND v(dout1_24) AT=1800.05n

.meas tran vdout1_25ck1790 FIND v(dout1_25) AT=1800.05n

.meas tran vdout1_26ck1790 FIND v(dout1_26) AT=1800.05n

.meas tran vdout1_27ck1790 FIND v(dout1_27) AT=1800.05n

.meas tran vdout1_0ck1830 FIND v(dout1_0) AT=1840.05n

.meas tran vdout1_1ck1830 FIND v(dout1_1) AT=1840.05n

.meas tran vdout1_2ck1830 FIND v(dout1_2) AT=1840.05n

.meas tran vdout1_3ck1830 FIND v(dout1_3) AT=1840.05n

.meas tran vdout1_4ck1830 FIND v(dout1_4) AT=1840.05n

.meas tran vdout1_5ck1830 FIND v(dout1_5) AT=1840.05n

.meas tran vdout1_6ck1830 FIND v(dout1_6) AT=1840.05n

.meas tran vdout1_7ck1830 FIND v(dout1_7) AT=1840.05n

.meas tran vdout1_8ck1830 FIND v(dout1_8) AT=1840.05n

.meas tran vdout1_9ck1830 FIND v(dout1_9) AT=1840.05n

.meas tran vdout1_10ck1830 FIND v(dout1_10) AT=1840.05n

.meas tran vdout1_11ck1830 FIND v(dout1_11) AT=1840.05n

.meas tran vdout1_12ck1830 FIND v(dout1_12) AT=1840.05n

.meas tran vdout1_13ck1830 FIND v(dout1_13) AT=1840.05n

.meas tran vdout1_14ck1830 FIND v(dout1_14) AT=1840.05n

.meas tran vdout1_15ck1830 FIND v(dout1_15) AT=1840.05n

.meas tran vdout1_16ck1830 FIND v(dout1_16) AT=1840.05n

.meas tran vdout1_17ck1830 FIND v(dout1_17) AT=1840.05n

.meas tran vdout1_18ck1830 FIND v(dout1_18) AT=1840.05n

.meas tran vdout1_19ck1830 FIND v(dout1_19) AT=1840.05n

.meas tran vdout1_20ck1830 FIND v(dout1_20) AT=1840.05n

.meas tran vdout1_21ck1830 FIND v(dout1_21) AT=1840.05n

.meas tran vdout1_22ck1830 FIND v(dout1_22) AT=1840.05n

.meas tran vdout1_23ck1830 FIND v(dout1_23) AT=1840.05n

.meas tran vdout1_24ck1830 FIND v(dout1_24) AT=1840.05n

.meas tran vdout1_25ck1830 FIND v(dout1_25) AT=1840.05n

.meas tran vdout1_26ck1830 FIND v(dout1_26) AT=1840.05n

.meas tran vdout1_27ck1830 FIND v(dout1_27) AT=1840.05n

.meas tran vdout1_0ck1890 FIND v(dout1_0) AT=1900.05n

.meas tran vdout1_1ck1890 FIND v(dout1_1) AT=1900.05n

.meas tran vdout1_2ck1890 FIND v(dout1_2) AT=1900.05n

.meas tran vdout1_3ck1890 FIND v(dout1_3) AT=1900.05n

.meas tran vdout1_4ck1890 FIND v(dout1_4) AT=1900.05n

.meas tran vdout1_5ck1890 FIND v(dout1_5) AT=1900.05n

.meas tran vdout1_6ck1890 FIND v(dout1_6) AT=1900.05n

.meas tran vdout1_7ck1890 FIND v(dout1_7) AT=1900.05n

.meas tran vdout1_8ck1890 FIND v(dout1_8) AT=1900.05n

.meas tran vdout1_9ck1890 FIND v(dout1_9) AT=1900.05n

.meas tran vdout1_10ck1890 FIND v(dout1_10) AT=1900.05n

.meas tran vdout1_11ck1890 FIND v(dout1_11) AT=1900.05n

.meas tran vdout1_12ck1890 FIND v(dout1_12) AT=1900.05n

.meas tran vdout1_13ck1890 FIND v(dout1_13) AT=1900.05n

.meas tran vdout1_14ck1890 FIND v(dout1_14) AT=1900.05n

.meas tran vdout1_15ck1890 FIND v(dout1_15) AT=1900.05n

.meas tran vdout1_16ck1890 FIND v(dout1_16) AT=1900.05n

.meas tran vdout1_17ck1890 FIND v(dout1_17) AT=1900.05n

.meas tran vdout1_18ck1890 FIND v(dout1_18) AT=1900.05n

.meas tran vdout1_19ck1890 FIND v(dout1_19) AT=1900.05n

.meas tran vdout1_20ck1890 FIND v(dout1_20) AT=1900.05n

.meas tran vdout1_21ck1890 FIND v(dout1_21) AT=1900.05n

.meas tran vdout1_22ck1890 FIND v(dout1_22) AT=1900.05n

.meas tran vdout1_23ck1890 FIND v(dout1_23) AT=1900.05n

.meas tran vdout1_24ck1890 FIND v(dout1_24) AT=1900.05n

.meas tran vdout1_25ck1890 FIND v(dout1_25) AT=1900.05n

.meas tran vdout1_26ck1890 FIND v(dout1_26) AT=1900.05n

.meas tran vdout1_27ck1890 FIND v(dout1_27) AT=1900.05n

.meas tran vdout1_0ck1900 FIND v(dout1_0) AT=1910.05n

.meas tran vdout1_1ck1900 FIND v(dout1_1) AT=1910.05n

.meas tran vdout1_2ck1900 FIND v(dout1_2) AT=1910.05n

.meas tran vdout1_3ck1900 FIND v(dout1_3) AT=1910.05n

.meas tran vdout1_4ck1900 FIND v(dout1_4) AT=1910.05n

.meas tran vdout1_5ck1900 FIND v(dout1_5) AT=1910.05n

.meas tran vdout1_6ck1900 FIND v(dout1_6) AT=1910.05n

.meas tran vdout1_7ck1900 FIND v(dout1_7) AT=1910.05n

.meas tran vdout1_8ck1900 FIND v(dout1_8) AT=1910.05n

.meas tran vdout1_9ck1900 FIND v(dout1_9) AT=1910.05n

.meas tran vdout1_10ck1900 FIND v(dout1_10) AT=1910.05n

.meas tran vdout1_11ck1900 FIND v(dout1_11) AT=1910.05n

.meas tran vdout1_12ck1900 FIND v(dout1_12) AT=1910.05n

.meas tran vdout1_13ck1900 FIND v(dout1_13) AT=1910.05n

.meas tran vdout1_14ck1900 FIND v(dout1_14) AT=1910.05n

.meas tran vdout1_15ck1900 FIND v(dout1_15) AT=1910.05n

.meas tran vdout1_16ck1900 FIND v(dout1_16) AT=1910.05n

.meas tran vdout1_17ck1900 FIND v(dout1_17) AT=1910.05n

.meas tran vdout1_18ck1900 FIND v(dout1_18) AT=1910.05n

.meas tran vdout1_19ck1900 FIND v(dout1_19) AT=1910.05n

.meas tran vdout1_20ck1900 FIND v(dout1_20) AT=1910.05n

.meas tran vdout1_21ck1900 FIND v(dout1_21) AT=1910.05n

.meas tran vdout1_22ck1900 FIND v(dout1_22) AT=1910.05n

.meas tran vdout1_23ck1900 FIND v(dout1_23) AT=1910.05n

.meas tran vdout1_24ck1900 FIND v(dout1_24) AT=1910.05n

.meas tran vdout1_25ck1900 FIND v(dout1_25) AT=1910.05n

.meas tran vdout1_26ck1900 FIND v(dout1_26) AT=1910.05n

.meas tran vdout1_27ck1900 FIND v(dout1_27) AT=1910.05n

.meas tran vdout1_0ck1920 FIND v(dout1_0) AT=1930.05n

.meas tran vdout1_1ck1920 FIND v(dout1_1) AT=1930.05n

.meas tran vdout1_2ck1920 FIND v(dout1_2) AT=1930.05n

.meas tran vdout1_3ck1920 FIND v(dout1_3) AT=1930.05n

.meas tran vdout1_4ck1920 FIND v(dout1_4) AT=1930.05n

.meas tran vdout1_5ck1920 FIND v(dout1_5) AT=1930.05n

.meas tran vdout1_6ck1920 FIND v(dout1_6) AT=1930.05n

.meas tran vdout1_7ck1920 FIND v(dout1_7) AT=1930.05n

.meas tran vdout1_8ck1920 FIND v(dout1_8) AT=1930.05n

.meas tran vdout1_9ck1920 FIND v(dout1_9) AT=1930.05n

.meas tran vdout1_10ck1920 FIND v(dout1_10) AT=1930.05n

.meas tran vdout1_11ck1920 FIND v(dout1_11) AT=1930.05n

.meas tran vdout1_12ck1920 FIND v(dout1_12) AT=1930.05n

.meas tran vdout1_13ck1920 FIND v(dout1_13) AT=1930.05n

.meas tran vdout1_14ck1920 FIND v(dout1_14) AT=1930.05n

.meas tran vdout1_15ck1920 FIND v(dout1_15) AT=1930.05n

.meas tran vdout1_16ck1920 FIND v(dout1_16) AT=1930.05n

.meas tran vdout1_17ck1920 FIND v(dout1_17) AT=1930.05n

.meas tran vdout1_18ck1920 FIND v(dout1_18) AT=1930.05n

.meas tran vdout1_19ck1920 FIND v(dout1_19) AT=1930.05n

.meas tran vdout1_20ck1920 FIND v(dout1_20) AT=1930.05n

.meas tran vdout1_21ck1920 FIND v(dout1_21) AT=1930.05n

.meas tran vdout1_22ck1920 FIND v(dout1_22) AT=1930.05n

.meas tran vdout1_23ck1920 FIND v(dout1_23) AT=1930.05n

.meas tran vdout1_24ck1920 FIND v(dout1_24) AT=1930.05n

.meas tran vdout1_25ck1920 FIND v(dout1_25) AT=1930.05n

.meas tran vdout1_26ck1920 FIND v(dout1_26) AT=1930.05n

.meas tran vdout1_27ck1920 FIND v(dout1_27) AT=1930.05n

.meas tran vdout1_0ck1960 FIND v(dout1_0) AT=1970.05n

.meas tran vdout1_1ck1960 FIND v(dout1_1) AT=1970.05n

.meas tran vdout1_2ck1960 FIND v(dout1_2) AT=1970.05n

.meas tran vdout1_3ck1960 FIND v(dout1_3) AT=1970.05n

.meas tran vdout1_4ck1960 FIND v(dout1_4) AT=1970.05n

.meas tran vdout1_5ck1960 FIND v(dout1_5) AT=1970.05n

.meas tran vdout1_6ck1960 FIND v(dout1_6) AT=1970.05n

.meas tran vdout1_7ck1960 FIND v(dout1_7) AT=1970.05n

.meas tran vdout1_8ck1960 FIND v(dout1_8) AT=1970.05n

.meas tran vdout1_9ck1960 FIND v(dout1_9) AT=1970.05n

.meas tran vdout1_10ck1960 FIND v(dout1_10) AT=1970.05n

.meas tran vdout1_11ck1960 FIND v(dout1_11) AT=1970.05n

.meas tran vdout1_12ck1960 FIND v(dout1_12) AT=1970.05n

.meas tran vdout1_13ck1960 FIND v(dout1_13) AT=1970.05n

.meas tran vdout1_14ck1960 FIND v(dout1_14) AT=1970.05n

.meas tran vdout1_15ck1960 FIND v(dout1_15) AT=1970.05n

.meas tran vdout1_16ck1960 FIND v(dout1_16) AT=1970.05n

.meas tran vdout1_17ck1960 FIND v(dout1_17) AT=1970.05n

.meas tran vdout1_18ck1960 FIND v(dout1_18) AT=1970.05n

.meas tran vdout1_19ck1960 FIND v(dout1_19) AT=1970.05n

.meas tran vdout1_20ck1960 FIND v(dout1_20) AT=1970.05n

.meas tran vdout1_21ck1960 FIND v(dout1_21) AT=1970.05n

.meas tran vdout1_22ck1960 FIND v(dout1_22) AT=1970.05n

.meas tran vdout1_23ck1960 FIND v(dout1_23) AT=1970.05n

.meas tran vdout1_24ck1960 FIND v(dout1_24) AT=1970.05n

.meas tran vdout1_25ck1960 FIND v(dout1_25) AT=1970.05n

.meas tran vdout1_26ck1960 FIND v(dout1_26) AT=1970.05n

.meas tran vdout1_27ck1960 FIND v(dout1_27) AT=1970.05n

.meas tran vdout1_0ck2000 FIND v(dout1_0) AT=2010.05n

.meas tran vdout1_1ck2000 FIND v(dout1_1) AT=2010.05n

.meas tran vdout1_2ck2000 FIND v(dout1_2) AT=2010.05n

.meas tran vdout1_3ck2000 FIND v(dout1_3) AT=2010.05n

.meas tran vdout1_4ck2000 FIND v(dout1_4) AT=2010.05n

.meas tran vdout1_5ck2000 FIND v(dout1_5) AT=2010.05n

.meas tran vdout1_6ck2000 FIND v(dout1_6) AT=2010.05n

.meas tran vdout1_7ck2000 FIND v(dout1_7) AT=2010.05n

.meas tran vdout1_8ck2000 FIND v(dout1_8) AT=2010.05n

.meas tran vdout1_9ck2000 FIND v(dout1_9) AT=2010.05n

.meas tran vdout1_10ck2000 FIND v(dout1_10) AT=2010.05n

.meas tran vdout1_11ck2000 FIND v(dout1_11) AT=2010.05n

.meas tran vdout1_12ck2000 FIND v(dout1_12) AT=2010.05n

.meas tran vdout1_13ck2000 FIND v(dout1_13) AT=2010.05n

.meas tran vdout1_14ck2000 FIND v(dout1_14) AT=2010.05n

.meas tran vdout1_15ck2000 FIND v(dout1_15) AT=2010.05n

.meas tran vdout1_16ck2000 FIND v(dout1_16) AT=2010.05n

.meas tran vdout1_17ck2000 FIND v(dout1_17) AT=2010.05n

.meas tran vdout1_18ck2000 FIND v(dout1_18) AT=2010.05n

.meas tran vdout1_19ck2000 FIND v(dout1_19) AT=2010.05n

.meas tran vdout1_20ck2000 FIND v(dout1_20) AT=2010.05n

.meas tran vdout1_21ck2000 FIND v(dout1_21) AT=2010.05n

.meas tran vdout1_22ck2000 FIND v(dout1_22) AT=2010.05n

.meas tran vdout1_23ck2000 FIND v(dout1_23) AT=2010.05n

.meas tran vdout1_24ck2000 FIND v(dout1_24) AT=2010.05n

.meas tran vdout1_25ck2000 FIND v(dout1_25) AT=2010.05n

.meas tran vdout1_26ck2000 FIND v(dout1_26) AT=2010.05n

.meas tran vdout1_27ck2000 FIND v(dout1_27) AT=2010.05n

.meas tran vdout1_0ck2010 FIND v(dout1_0) AT=2020.05n

.meas tran vdout1_1ck2010 FIND v(dout1_1) AT=2020.05n

.meas tran vdout1_2ck2010 FIND v(dout1_2) AT=2020.05n

.meas tran vdout1_3ck2010 FIND v(dout1_3) AT=2020.05n

.meas tran vdout1_4ck2010 FIND v(dout1_4) AT=2020.05n

.meas tran vdout1_5ck2010 FIND v(dout1_5) AT=2020.05n

.meas tran vdout1_6ck2010 FIND v(dout1_6) AT=2020.05n

.meas tran vdout1_7ck2010 FIND v(dout1_7) AT=2020.05n

.meas tran vdout1_8ck2010 FIND v(dout1_8) AT=2020.05n

.meas tran vdout1_9ck2010 FIND v(dout1_9) AT=2020.05n

.meas tran vdout1_10ck2010 FIND v(dout1_10) AT=2020.05n

.meas tran vdout1_11ck2010 FIND v(dout1_11) AT=2020.05n

.meas tran vdout1_12ck2010 FIND v(dout1_12) AT=2020.05n

.meas tran vdout1_13ck2010 FIND v(dout1_13) AT=2020.05n

.meas tran vdout1_14ck2010 FIND v(dout1_14) AT=2020.05n

.meas tran vdout1_15ck2010 FIND v(dout1_15) AT=2020.05n

.meas tran vdout1_16ck2010 FIND v(dout1_16) AT=2020.05n

.meas tran vdout1_17ck2010 FIND v(dout1_17) AT=2020.05n

.meas tran vdout1_18ck2010 FIND v(dout1_18) AT=2020.05n

.meas tran vdout1_19ck2010 FIND v(dout1_19) AT=2020.05n

.meas tran vdout1_20ck2010 FIND v(dout1_20) AT=2020.05n

.meas tran vdout1_21ck2010 FIND v(dout1_21) AT=2020.05n

.meas tran vdout1_22ck2010 FIND v(dout1_22) AT=2020.05n

.meas tran vdout1_23ck2010 FIND v(dout1_23) AT=2020.05n

.meas tran vdout1_24ck2010 FIND v(dout1_24) AT=2020.05n

.meas tran vdout1_25ck2010 FIND v(dout1_25) AT=2020.05n

.meas tran vdout1_26ck2010 FIND v(dout1_26) AT=2020.05n

.meas tran vdout1_27ck2010 FIND v(dout1_27) AT=2020.05n

.meas tran vdout1_0ck2020 FIND v(dout1_0) AT=2030.05n

.meas tran vdout1_1ck2020 FIND v(dout1_1) AT=2030.05n

.meas tran vdout1_2ck2020 FIND v(dout1_2) AT=2030.05n

.meas tran vdout1_3ck2020 FIND v(dout1_3) AT=2030.05n

.meas tran vdout1_4ck2020 FIND v(dout1_4) AT=2030.05n

.meas tran vdout1_5ck2020 FIND v(dout1_5) AT=2030.05n

.meas tran vdout1_6ck2020 FIND v(dout1_6) AT=2030.05n

.meas tran vdout1_7ck2020 FIND v(dout1_7) AT=2030.05n

.meas tran vdout1_8ck2020 FIND v(dout1_8) AT=2030.05n

.meas tran vdout1_9ck2020 FIND v(dout1_9) AT=2030.05n

.meas tran vdout1_10ck2020 FIND v(dout1_10) AT=2030.05n

.meas tran vdout1_11ck2020 FIND v(dout1_11) AT=2030.05n

.meas tran vdout1_12ck2020 FIND v(dout1_12) AT=2030.05n

.meas tran vdout1_13ck2020 FIND v(dout1_13) AT=2030.05n

.meas tran vdout1_14ck2020 FIND v(dout1_14) AT=2030.05n

.meas tran vdout1_15ck2020 FIND v(dout1_15) AT=2030.05n

.meas tran vdout1_16ck2020 FIND v(dout1_16) AT=2030.05n

.meas tran vdout1_17ck2020 FIND v(dout1_17) AT=2030.05n

.meas tran vdout1_18ck2020 FIND v(dout1_18) AT=2030.05n

.meas tran vdout1_19ck2020 FIND v(dout1_19) AT=2030.05n

.meas tran vdout1_20ck2020 FIND v(dout1_20) AT=2030.05n

.meas tran vdout1_21ck2020 FIND v(dout1_21) AT=2030.05n

.meas tran vdout1_22ck2020 FIND v(dout1_22) AT=2030.05n

.meas tran vdout1_23ck2020 FIND v(dout1_23) AT=2030.05n

.meas tran vdout1_24ck2020 FIND v(dout1_24) AT=2030.05n

.meas tran vdout1_25ck2020 FIND v(dout1_25) AT=2030.05n

.meas tran vdout1_26ck2020 FIND v(dout1_26) AT=2030.05n

.meas tran vdout1_27ck2020 FIND v(dout1_27) AT=2030.05n

.meas tran vdout1_0ck2030 FIND v(dout1_0) AT=2040.05n

.meas tran vdout1_1ck2030 FIND v(dout1_1) AT=2040.05n

.meas tran vdout1_2ck2030 FIND v(dout1_2) AT=2040.05n

.meas tran vdout1_3ck2030 FIND v(dout1_3) AT=2040.05n

.meas tran vdout1_4ck2030 FIND v(dout1_4) AT=2040.05n

.meas tran vdout1_5ck2030 FIND v(dout1_5) AT=2040.05n

.meas tran vdout1_6ck2030 FIND v(dout1_6) AT=2040.05n

.meas tran vdout1_7ck2030 FIND v(dout1_7) AT=2040.05n

.meas tran vdout1_8ck2030 FIND v(dout1_8) AT=2040.05n

.meas tran vdout1_9ck2030 FIND v(dout1_9) AT=2040.05n

.meas tran vdout1_10ck2030 FIND v(dout1_10) AT=2040.05n

.meas tran vdout1_11ck2030 FIND v(dout1_11) AT=2040.05n

.meas tran vdout1_12ck2030 FIND v(dout1_12) AT=2040.05n

.meas tran vdout1_13ck2030 FIND v(dout1_13) AT=2040.05n

.meas tran vdout1_14ck2030 FIND v(dout1_14) AT=2040.05n

.meas tran vdout1_15ck2030 FIND v(dout1_15) AT=2040.05n

.meas tran vdout1_16ck2030 FIND v(dout1_16) AT=2040.05n

.meas tran vdout1_17ck2030 FIND v(dout1_17) AT=2040.05n

.meas tran vdout1_18ck2030 FIND v(dout1_18) AT=2040.05n

.meas tran vdout1_19ck2030 FIND v(dout1_19) AT=2040.05n

.meas tran vdout1_20ck2030 FIND v(dout1_20) AT=2040.05n

.meas tran vdout1_21ck2030 FIND v(dout1_21) AT=2040.05n

.meas tran vdout1_22ck2030 FIND v(dout1_22) AT=2040.05n

.meas tran vdout1_23ck2030 FIND v(dout1_23) AT=2040.05n

.meas tran vdout1_24ck2030 FIND v(dout1_24) AT=2040.05n

.meas tran vdout1_25ck2030 FIND v(dout1_25) AT=2040.05n

.meas tran vdout1_26ck2030 FIND v(dout1_26) AT=2040.05n

.meas tran vdout1_27ck2030 FIND v(dout1_27) AT=2040.05n
